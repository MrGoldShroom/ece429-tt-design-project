* NGSPICE file created from barrelShifter.ext - technology: sky130A

* Black-box entry subcircuit for sky130_fd_sc_hd__decap_3 abstract view
.subckt sky130_fd_sc_hd__decap_3 VGND VNB VPB VPWR
.ends

* Black-box entry subcircuit for sky130_fd_sc_hd__fill_1 abstract view
.subckt sky130_fd_sc_hd__fill_1 VGND VNB VPB VPWR
.ends

* Black-box entry subcircuit for sky130_fd_sc_hd__and4b_1 abstract view
.subckt sky130_fd_sc_hd__and4b_1 A_N B C D VGND VNB VPB VPWR X
.ends

* Black-box entry subcircuit for sky130_fd_sc_hd__a221o_1 abstract view
.subckt sky130_fd_sc_hd__a221o_1 A1 A2 B1 B2 C1 VGND VNB VPB VPWR X
.ends

* Black-box entry subcircuit for sky130_fd_sc_hd__and3b_1 abstract view
.subckt sky130_fd_sc_hd__and3b_1 A_N B C VGND VNB VPB VPWR X
.ends

* Black-box entry subcircuit for sky130_fd_sc_hd__tapvpwrvgnd_1 abstract view
.subckt sky130_fd_sc_hd__tapvpwrvgnd_1 VGND VPWR
.ends

* Black-box entry subcircuit for sky130_fd_sc_hd__o32a_1 abstract view
.subckt sky130_fd_sc_hd__o32a_1 A1 A2 A3 B1 B2 VGND VNB VPB VPWR X
.ends

* Black-box entry subcircuit for sky130_fd_sc_hd__or4_1 abstract view
.subckt sky130_fd_sc_hd__or4_1 A B C D VGND VNB VPB VPWR X
.ends

* Black-box entry subcircuit for sky130_fd_sc_hd__fill_2 abstract view
.subckt sky130_fd_sc_hd__fill_2 VGND VNB VPB VPWR
.ends

* Black-box entry subcircuit for sky130_fd_sc_hd__buf_2 abstract view
.subckt sky130_fd_sc_hd__buf_2 A VGND VNB VPB VPWR X
.ends

* Black-box entry subcircuit for sky130_fd_sc_hd__and4bb_1 abstract view
.subckt sky130_fd_sc_hd__and4bb_1 A_N B_N C D VGND VNB VPB VPWR X
.ends

* Black-box entry subcircuit for sky130_fd_sc_hd__a22o_1 abstract view
.subckt sky130_fd_sc_hd__a22o_1 A1 A2 B1 B2 VGND VNB VPB VPWR X
.ends

* Black-box entry subcircuit for sky130_fd_sc_hd__and2_1 abstract view
.subckt sky130_fd_sc_hd__and2_1 A B VGND VNB VPB VPWR X
.ends

* Black-box entry subcircuit for sky130_fd_sc_hd__buf_1 abstract view
.subckt sky130_fd_sc_hd__buf_1 A VGND VNB VPB VPWR X
.ends

* Black-box entry subcircuit for sky130_fd_sc_hd__o22a_1 abstract view
.subckt sky130_fd_sc_hd__o22a_1 A1 A2 B1 B2 VGND VNB VPB VPWR X
.ends

* Black-box entry subcircuit for sky130_fd_sc_hd__clkbuf_2 abstract view
.subckt sky130_fd_sc_hd__clkbuf_2 A VGND VNB VPB VPWR X
.ends

* Black-box entry subcircuit for sky130_fd_sc_hd__a2111o_1 abstract view
.subckt sky130_fd_sc_hd__a2111o_1 A1 A2 B1 C1 D1 VGND VNB VPB VPWR X
.ends

* Black-box entry subcircuit for sky130_fd_sc_hd__o211a_1 abstract view
.subckt sky130_fd_sc_hd__o211a_1 A1 A2 B1 C1 VGND VNB VPB VPWR X
.ends

* Black-box entry subcircuit for sky130_fd_sc_hd__clkbuf_1 abstract view
.subckt sky130_fd_sc_hd__clkbuf_1 A VGND VNB VPB VPWR X
.ends

* Black-box entry subcircuit for sky130_fd_sc_hd__nor3b_2 abstract view
.subckt sky130_fd_sc_hd__nor3b_2 A B C_N VGND VNB VPB VPWR Y
.ends

* Black-box entry subcircuit for sky130_fd_sc_hd__nor3_1 abstract view
.subckt sky130_fd_sc_hd__nor3_1 A B C VGND VNB VPB VPWR Y
.ends

* Black-box entry subcircuit for sky130_fd_sc_hd__nand3_4 abstract view
.subckt sky130_fd_sc_hd__nand3_4 A B C VGND VNB VPB VPWR Y
.ends

* Black-box entry subcircuit for sky130_fd_sc_hd__nor3b_1 abstract view
.subckt sky130_fd_sc_hd__nor3b_1 A B C_N VGND VNB VPB VPWR Y
.ends

.subckt barrelShifter VGND VPWR amt[0] amt[1] amt[2] data[0] data[1] data[2] data[3]
+ data[4] data[5] data[6] data[7] result[0] result[1] result[2] result[3] result[4]
+ result[5] result[6] result[7]
XFILLER_12_32 VGND VGND VPWR VPWR sky130_fd_sc_hd__decap_3
XFILLER_12_21 VGND VGND VPWR VPWR sky130_fd_sc_hd__decap_3
XFILLER_3_23 VGND VGND VPWR VPWR sky130_fd_sc_hd__decap_3
XFILLER_9_77 VGND VGND VPWR VPWR sky130_fd_sc_hd__fill_1
XFILLER_9_44 VGND VGND VPWR VPWR sky130_fd_sc_hd__decap_3
X_062_ net29 net9 net24 net33 VGND VGND VPWR VPWR _006_ sky130_fd_sc_hd__and4b_1
XFILLER_0_35 VGND VGND VPWR VPWR sky130_fd_sc_hd__fill_1
XFILLER_0_57 VGND VGND VPWR VPWR sky130_fd_sc_hd__decap_3
XPHY_EDGE_ROW_12_Left_25 VGND VGND VPWR VPWR sky130_fd_sc_hd__decap_3
X_114_ net8 _005_ net20 net4 _050_ VGND VGND VPWR VPWR _051_ sky130_fd_sc_hd__a221o_1
XFILLER_6_23 VGND VGND VPWR VPWR sky130_fd_sc_hd__decap_3
XFILLER_3_35 VGND VGND VPWR VPWR sky130_fd_sc_hd__decap_3
XFILLER_3_57 VGND VGND VPWR VPWR sky130_fd_sc_hd__decap_3
XPHY_EDGE_ROW_12_Right_12 VGND VGND VPWR VPWR sky130_fd_sc_hd__decap_3
XFILLER_12_66 VGND VGND VPWR VPWR sky130_fd_sc_hd__decap_3
XFILLER_12_44 VGND VGND VPWR VPWR sky130_fd_sc_hd__decap_3
XPHY_EDGE_ROW_0_Left_13 VGND VGND VPWR VPWR sky130_fd_sc_hd__decap_3
XFILLER_9_23 VGND VGND VPWR VPWR sky130_fd_sc_hd__decap_3
X_061_ net26 net31 net22 VGND VGND VPWR VPWR _005_ sky130_fd_sc_hd__and3b_1
X_113_ net32 net27 net9 net23 VGND VGND VPWR VPWR _050_ sky130_fd_sc_hd__and4b_1
XPHY_EDGE_ROW_6_Right_6 VGND VGND VPWR VPWR sky130_fd_sc_hd__decap_3
XFILLER_6_46 VGND VGND VPWR VPWR sky130_fd_sc_hd__decap_3
XFILLER_6_13 VGND VGND VPWR VPWR sky130_fd_sc_hd__fill_1
XFILLER_12_12 VGND VGND VPWR VPWR sky130_fd_sc_hd__decap_3
XTAP_TAPCELL_ROW_8_35 VGND VPWR sky130_fd_sc_hd__tapvpwrvgnd_1
X_060_ net4 net21 _002_ net6 _003_ VGND VGND VPWR VPWR _004_ sky130_fd_sc_hd__a221o_1
XFILLER_6_36 VGND VGND VPWR VPWR sky130_fd_sc_hd__decap_3
X_112_ _043_ _044_ _049_ _000_ net9 VGND VGND VPWR VPWR net18 sky130_fd_sc_hd__o32a_1
XFILLER_12_57 VGND VGND VPWR VPWR sky130_fd_sc_hd__decap_3
XFILLER_12_35 VGND VGND VPWR VPWR sky130_fd_sc_hd__decap_3
XFILLER_12_24 VGND VGND VPWR VPWR sky130_fd_sc_hd__decap_3
XFILLER_3_26 VGND VGND VPWR VPWR sky130_fd_sc_hd__fill_1
XFILLER_9_47 VGND VGND VPWR VPWR sky130_fd_sc_hd__decap_3
X_111_ _045_ _046_ _047_ _048_ VGND VGND VPWR VPWR _049_ sky130_fd_sc_hd__or4_1
XFILLER_6_26 VGND VGND VPWR VPWR sky130_fd_sc_hd__fill_2
Xoutput12 net12 VGND VGND VPWR VPWR result[0] sky130_fd_sc_hd__buf_2
XFILLER_3_38 VGND VGND VPWR VPWR sky130_fd_sc_hd__decap_3
XFILLER_12_69 VGND VGND VPWR VPWR sky130_fd_sc_hd__decap_3
XFILLER_12_47 VGND VGND VPWR VPWR sky130_fd_sc_hd__decap_3
XFILLER_9_26 VGND VGND VPWR VPWR sky130_fd_sc_hd__decap_3
XPHY_EDGE_ROW_4_Left_17 VGND VGND VPWR VPWR sky130_fd_sc_hd__decap_3
XPHY_EDGE_ROW_7_Left_20 VGND VGND VPWR VPWR sky130_fd_sc_hd__decap_3
X_110_ net31 net26 net6 net22 VGND VGND VPWR VPWR _048_ sky130_fd_sc_hd__and4bb_1
XFILLER_6_49 VGND VGND VPWR VPWR sky130_fd_sc_hd__decap_3
Xoutput13 net13 VGND VGND VPWR VPWR result[1] sky130_fd_sc_hd__buf_2
XFILLER_12_15 VGND VGND VPWR VPWR sky130_fd_sc_hd__decap_3
XFILLER_9_38 VGND VGND VPWR VPWR sky130_fd_sc_hd__decap_3
XFILLER_1_3 VGND VGND VPWR VPWR sky130_fd_sc_hd__fill_1
XFILLER_0_29 VGND VGND VPWR VPWR sky130_fd_sc_hd__fill_2
XFILLER_4_60 VGND VGND VPWR VPWR sky130_fd_sc_hd__fill_1
XFILLER_6_39 VGND VGND VPWR VPWR sky130_fd_sc_hd__decap_3
XFILLER_7_60 VGND VGND VPWR VPWR sky130_fd_sc_hd__decap_3
XTAP_TAPCELL_ROW_2_29 VGND VPWR sky130_fd_sc_hd__tapvpwrvgnd_1
Xoutput14 net14 VGND VGND VPWR VPWR result[2] sky130_fd_sc_hd__buf_2
XFILLER_12_38 VGND VGND VPWR VPWR sky130_fd_sc_hd__decap_3
XFILLER_12_27 VGND VGND VPWR VPWR sky130_fd_sc_hd__fill_1
X_099_ net23 net27 net10 net32 VGND VGND VPWR VPWR _038_ sky130_fd_sc_hd__and4bb_1
Xoutput15 net15 VGND VGND VPWR VPWR result[3] sky130_fd_sc_hd__buf_2
XFILLER_7_72 VGND VGND VPWR VPWR sky130_fd_sc_hd__fill_2
XPHY_EDGE_ROW_1_Right_1 VGND VGND VPWR VPWR sky130_fd_sc_hd__decap_3
XTAP_TAPCELL_ROW_12_39 VGND VPWR sky130_fd_sc_hd__tapvpwrvgnd_1
XFILLER_9_29 VGND VGND VPWR VPWR sky130_fd_sc_hd__fill_1
XFILLER_4_73 VGND VGND VPWR VPWR sky130_fd_sc_hd__fill_1
X_098_ net9 net21 _002_ net11 VGND VGND VPWR VPWR _037_ sky130_fd_sc_hd__a22o_1
XFILLER_11_7 VGND VGND VPWR VPWR sky130_fd_sc_hd__fill_1
Xoutput16 net16 VGND VGND VPWR VPWR result[4] sky130_fd_sc_hd__buf_2
XTAP_TAPCELL_ROW_3_30 VGND VPWR sky130_fd_sc_hd__tapvpwrvgnd_1
XFILLER_12_29 VGND VGND VPWR VPWR sky130_fd_sc_hd__decap_3
XFILLER_12_18 VGND VGND VPWR VPWR sky130_fd_sc_hd__decap_3
X_097_ net6 _005_ VGND VGND VPWR VPWR _036_ sky130_fd_sc_hd__and2_1
XFILLER_1_75 VGND VGND VPWR VPWR sky130_fd_sc_hd__decap_3
XPHY_EDGE_ROW_11_Left_24 VGND VGND VPWR VPWR sky130_fd_sc_hd__decap_3
XFILLER_10_51 VGND VGND VPWR VPWR sky130_fd_sc_hd__decap_3
Xoutput17 net17 VGND VGND VPWR VPWR result[5] sky130_fd_sc_hd__buf_2
XFILLER_7_63 VGND VGND VPWR VPWR sky130_fd_sc_hd__decap_3
Xfanout30 net2 VGND VGND VPWR VPWR net30 sky130_fd_sc_hd__buf_1
XFILLER_10_41 VGND VGND VPWR VPWR sky130_fd_sc_hd__decap_3
XFILLER_1_54 VGND VGND VPWR VPWR sky130_fd_sc_hd__fill_2
X_096_ net7 _000_ _034_ _035_ VGND VGND VPWR VPWR net16 sky130_fd_sc_hd__o22a_1
Xoutput18 net18 VGND VGND VPWR VPWR result[6] sky130_fd_sc_hd__buf_2
XPHY_EDGE_ROW_5_Right_5 VGND VGND VPWR VPWR sky130_fd_sc_hd__decap_3
X_079_ net6 net21 _002_ net8 _017_ VGND VGND VPWR VPWR _021_ sky130_fd_sc_hd__a221o_1
XFILLER_4_32 VGND VGND VPWR VPWR sky130_fd_sc_hd__decap_3
Xfanout31 net1 VGND VGND VPWR VPWR net31 sky130_fd_sc_hd__clkbuf_2
X_095_ net10 _002_ _031_ _032_ _033_ VGND VGND VPWR VPWR _035_ sky130_fd_sc_hd__a2111o_1
XFILLER_10_75 VGND VGND VPWR VPWR sky130_fd_sc_hd__decap_3
Xoutput19 net19 VGND VGND VPWR VPWR result[7] sky130_fd_sc_hd__buf_2
X_078_ net34 net29 net10 net25 VGND VGND VPWR VPWR _020_ sky130_fd_sc_hd__and4bb_1
XPHY_EDGE_ROW_11_Right_11 VGND VGND VPWR VPWR sky130_fd_sc_hd__decap_3
Xfanout32 net1 VGND VGND VPWR VPWR net32 sky130_fd_sc_hd__buf_1
XFILLER_10_54 VGND VGND VPWR VPWR sky130_fd_sc_hd__decap_3
X_094_ net8 net21 net20 net9 _030_ VGND VGND VPWR VPWR _034_ sky130_fd_sc_hd__a221o_1
XFILLER_7_66 VGND VGND VPWR VPWR sky130_fd_sc_hd__decap_3
XTAP_TAPCELL_ROW_6_33 VGND VPWR sky130_fd_sc_hd__tapvpwrvgnd_1
X_077_ net25 net9 net28 net34 VGND VGND VPWR VPWR _019_ sky130_fd_sc_hd__o211a_1
Xfanout33 net34 VGND VGND VPWR VPWR net33 sky130_fd_sc_hd__clkbuf_2
X_093_ net31 net26 net6 net22 VGND VGND VPWR VPWR _033_ sky130_fd_sc_hd__and4b_1
Xfanout22 net3 VGND VGND VPWR VPWR net22 sky130_fd_sc_hd__clkbuf_2
XPHY_EDGE_ROW_3_Left_16 VGND VGND VPWR VPWR sky130_fd_sc_hd__decap_3
Xinput1 amt[0] VGND VGND VPWR VPWR net1 sky130_fd_sc_hd__buf_1
XFILLER_10_44 VGND VGND VPWR VPWR sky130_fd_sc_hd__decap_3
X_076_ net28 net11 net25 net34 VGND VGND VPWR VPWR _018_ sky130_fd_sc_hd__and4b_1
XPHY_EDGE_ROW_9_Right_9 VGND VGND VPWR VPWR sky130_fd_sc_hd__decap_3
X_059_ net33 net28 net8 net24 VGND VGND VPWR VPWR _003_ sky130_fd_sc_hd__and4bb_1
Xfanout34 net1 VGND VGND VPWR VPWR net34 sky130_fd_sc_hd__buf_2
Xfanout23 net3 VGND VGND VPWR VPWR net23 sky130_fd_sc_hd__buf_1
XFILLER_4_35 VGND VGND VPWR VPWR sky130_fd_sc_hd__fill_1
X_092_ net22 net11 net26 net31 VGND VGND VPWR VPWR _032_ sky130_fd_sc_hd__o211a_1
Xinput2 amt[1] VGND VGND VPWR VPWR net2 sky130_fd_sc_hd__clkbuf_1
XFILLER_7_57 VGND VGND VPWR VPWR sky130_fd_sc_hd__decap_3
X_058_ net24 net33 net28 VGND VGND VPWR VPWR _002_ sky130_fd_sc_hd__nor3b_2
Xmax_cap20 _008_ VGND VGND VPWR VPWR net20 sky130_fd_sc_hd__clkbuf_2
X_075_ net33 net28 net4 net24 VGND VGND VPWR VPWR _017_ sky130_fd_sc_hd__and4b_1
XTAP_TAPCELL_ROW_0_26 VGND VPWR sky130_fd_sc_hd__tapvpwrvgnd_1
Xfanout24 net25 VGND VGND VPWR VPWR net24 sky130_fd_sc_hd__clkbuf_2
XFILLER_10_57 VGND VGND VPWR VPWR sky130_fd_sc_hd__fill_2
X_091_ net31 net26 net4 net22 VGND VGND VPWR VPWR _031_ sky130_fd_sc_hd__and4bb_1
Xinput3 amt[2] VGND VGND VPWR VPWR net3 sky130_fd_sc_hd__buf_1
X_074_ net4 _000_ _015_ _016_ VGND VGND VPWR VPWR net13 sky130_fd_sc_hd__o22a_1
X_057_ net25 net34 net29 VGND VGND VPWR VPWR _001_ sky130_fd_sc_hd__nor3_1
Xmax_cap21 _001_ VGND VGND VPWR VPWR net21 sky130_fd_sc_hd__clkbuf_2
XFILLER_7_69 VGND VGND VPWR VPWR sky130_fd_sc_hd__decap_3
XPHY_EDGE_ROW_0_Right_0 VGND VGND VPWR VPWR sky130_fd_sc_hd__decap_3
XTAP_TAPCELL_ROW_0_27 VGND VPWR sky130_fd_sc_hd__tapvpwrvgnd_1
Xfanout25 net3 VGND VGND VPWR VPWR net25 sky130_fd_sc_hd__buf_2
X_109_ net31 net26 net8 net22 VGND VGND VPWR VPWR _047_ sky130_fd_sc_hd__and4b_1
XTAP_TAPCELL_ROW_9_36 VGND VPWR sky130_fd_sc_hd__tapvpwrvgnd_1
Xinput4 data[0] VGND VGND VPWR VPWR net4 sky130_fd_sc_hd__clkbuf_2
X_090_ net26 net5 net22 net31 VGND VGND VPWR VPWR _030_ sky130_fd_sc_hd__and4b_1
X_056_ net25 net34 net29 VGND VGND VPWR VPWR _000_ sky130_fd_sc_hd__nand3_4
X_073_ net7 _002_ _012_ _013_ _014_ VGND VGND VPWR VPWR _016_ sky130_fd_sc_hd__a2111o_1
X_108_ net22 net5 net26 net31 VGND VGND VPWR VPWR _046_ sky130_fd_sc_hd__o211a_1
Xfanout26 net30 VGND VGND VPWR VPWR net26 sky130_fd_sc_hd__clkbuf_2
Xinput5 data[1] VGND VGND VPWR VPWR net5 sky130_fd_sc_hd__clkbuf_2
XTAP_TAPCELL_ROW_10_37 VGND VPWR sky130_fd_sc_hd__tapvpwrvgnd_1
XFILLER_10_26 VGND VGND VPWR VPWR sky130_fd_sc_hd__fill_2
XFILLER_10_15 VGND VGND VPWR VPWR sky130_fd_sc_hd__fill_1
XFILLER_1_39 VGND VGND VPWR VPWR sky130_fd_sc_hd__fill_2
X_072_ net5 net21 net20 net6 _011_ VGND VGND VPWR VPWR _015_ sky130_fd_sc_hd__a221o_1
XPHY_EDGE_ROW_10_Left_23 VGND VGND VPWR VPWR sky130_fd_sc_hd__decap_3
Xfanout27 net30 VGND VGND VPWR VPWR net27 sky130_fd_sc_hd__buf_1
X_107_ net22 net31 net26 net4 VGND VGND VPWR VPWR _045_ sky130_fd_sc_hd__and4bb_1
XFILLER_5_60 VGND VGND VPWR VPWR sky130_fd_sc_hd__decap_3
Xinput6 data[2] VGND VGND VPWR VPWR net6 sky130_fd_sc_hd__clkbuf_2
X_071_ net33 net28 net9 net24 VGND VGND VPWR VPWR _014_ sky130_fd_sc_hd__and4bb_1
XFILLER_7_39 VGND VGND VPWR VPWR sky130_fd_sc_hd__fill_2
X_106_ net10 net21 net20 net11 VGND VGND VPWR VPWR _044_ sky130_fd_sc_hd__a22o_1
XPHY_EDGE_ROW_4_Right_4 VGND VGND VPWR VPWR sky130_fd_sc_hd__decap_3
Xfanout28 net29 VGND VGND VPWR VPWR net28 sky130_fd_sc_hd__clkbuf_2
XFILLER_4_18 VGND VGND VPWR VPWR sky130_fd_sc_hd__fill_2
XFILLER_4_29 VGND VGND VPWR VPWR sky130_fd_sc_hd__decap_3
XFILLER_5_72 VGND VGND VPWR VPWR sky130_fd_sc_hd__fill_2
Xinput7 data[3] VGND VGND VPWR VPWR net7 sky130_fd_sc_hd__clkbuf_2
X_070_ net24 net8 net28 net33 VGND VGND VPWR VPWR _013_ sky130_fd_sc_hd__o211a_1
XFILLER_11_60 VGND VGND VPWR VPWR sky130_fd_sc_hd__decap_3
Xinput10 data[6] VGND VGND VPWR VPWR net10 sky130_fd_sc_hd__clkbuf_2
X_105_ net7 _005_ VGND VGND VPWR VPWR _043_ sky130_fd_sc_hd__and2_1
XFILLER_6_7 VGND VGND VPWR VPWR sky130_fd_sc_hd__fill_1
XFILLER_5_51 VGND VGND VPWR VPWR sky130_fd_sc_hd__decap_3
Xfanout29 net30 VGND VGND VPWR VPWR net29 sky130_fd_sc_hd__buf_2
Xinput8 data[4] VGND VGND VPWR VPWR net8 sky130_fd_sc_hd__clkbuf_2
XFILLER_11_72 VGND VGND VPWR VPWR sky130_fd_sc_hd__decap_3
Xinput11 data[7] VGND VGND VPWR VPWR net11 sky130_fd_sc_hd__clkbuf_2
XFILLER_8_40 VGND VGND VPWR VPWR sky130_fd_sc_hd__decap_3
X_104_ _036_ _037_ _042_ _000_ net8 VGND VGND VPWR VPWR net17 sky130_fd_sc_hd__o32a_1
Xinput9 data[5] VGND VGND VPWR VPWR net9 sky130_fd_sc_hd__clkbuf_2
XPHY_EDGE_ROW_2_Left_15 VGND VGND VPWR VPWR sky130_fd_sc_hd__decap_3
XPHY_EDGE_ROW_10_Right_10 VGND VGND VPWR VPWR sky130_fd_sc_hd__decap_3
X_103_ _038_ _039_ _040_ _041_ VGND VGND VPWR VPWR _042_ sky130_fd_sc_hd__or4_1
XTAP_TAPCELL_ROW_4_31 VGND VPWR sky130_fd_sc_hd__tapvpwrvgnd_1
XPHY_EDGE_ROW_8_Right_8 VGND VGND VPWR VPWR sky130_fd_sc_hd__decap_3
XFILLER_11_63 VGND VGND VPWR VPWR sky130_fd_sc_hd__decap_3
XFILLER_11_52 VGND VGND VPWR VPWR sky130_fd_sc_hd__decap_3
X_102_ net32 net27 net5 net23 VGND VGND VPWR VPWR _041_ sky130_fd_sc_hd__and4bb_1
XFILLER_8_64 VGND VGND VPWR VPWR sky130_fd_sc_hd__fill_2
XFILLER_5_54 VGND VGND VPWR VPWR sky130_fd_sc_hd__fill_2
XFILLER_5_32 VGND VGND VPWR VPWR sky130_fd_sc_hd__decap_3
XFILLER_5_21 VGND VGND VPWR VPWR sky130_fd_sc_hd__decap_3
XFILLER_11_75 VGND VGND VPWR VPWR sky130_fd_sc_hd__decap_3
XFILLER_2_44 VGND VGND VPWR VPWR sky130_fd_sc_hd__fill_2
XFILLER_4_7 VGND VGND VPWR VPWR sky130_fd_sc_hd__fill_1
X_101_ net32 net27 net7 net23 VGND VGND VPWR VPWR _040_ sky130_fd_sc_hd__and4b_1
XFILLER_8_76 VGND VGND VPWR VPWR sky130_fd_sc_hd__fill_2
XFILLER_8_10 VGND VGND VPWR VPWR sky130_fd_sc_hd__decap_3
XFILLER_12_6 VGND VGND VPWR VPWR sky130_fd_sc_hd__decap_3
X_100_ net23 net4 net27 net32 VGND VGND VPWR VPWR _039_ sky130_fd_sc_hd__o211a_1
XPHY_EDGE_ROW_6_Left_19 VGND VGND VPWR VPWR sky130_fd_sc_hd__decap_3
XPHY_EDGE_ROW_9_Left_22 VGND VGND VPWR VPWR sky130_fd_sc_hd__decap_3
XFILLER_8_22 VGND VGND VPWR VPWR sky130_fd_sc_hd__decap_3
XFILLER_11_66 VGND VGND VPWR VPWR sky130_fd_sc_hd__decap_3
XFILLER_11_55 VGND VGND VPWR VPWR sky130_fd_sc_hd__fill_1
XFILLER_11_11 VGND VGND VPWR VPWR sky130_fd_sc_hd__fill_1
XTAP_TAPCELL_ROW_7_34 VGND VPWR sky130_fd_sc_hd__tapvpwrvgnd_1
XFILLER_0_3 VGND VGND VPWR VPWR sky130_fd_sc_hd__fill_2
XFILLER_5_57 VGND VGND VPWR VPWR sky130_fd_sc_hd__decap_3
XFILLER_5_35 VGND VGND VPWR VPWR sky130_fd_sc_hd__decap_3
XFILLER_5_24 VGND VGND VPWR VPWR sky130_fd_sc_hd__fill_1
XFILLER_12_9 VGND VGND VPWR VPWR sky130_fd_sc_hd__decap_3
XFILLER_8_13 VGND VGND VPWR VPWR sky130_fd_sc_hd__decap_3
X_089_ _023_ _024_ _029_ _000_ net6 VGND VGND VPWR VPWR net15 sky130_fd_sc_hd__o32a_1
XPHY_EDGE_ROW_3_Right_3 VGND VGND VPWR VPWR sky130_fd_sc_hd__decap_3
XFILLER_11_57 VGND VGND VPWR VPWR sky130_fd_sc_hd__decap_3
X_088_ _025_ _026_ _027_ _028_ VGND VGND VPWR VPWR _029_ sky130_fd_sc_hd__or4_1
XFILLER_8_25 VGND VGND VPWR VPWR sky130_fd_sc_hd__decap_3
XFILLER_11_69 VGND VGND VPWR VPWR sky130_fd_sc_hd__decap_3
XFILLER_11_25 VGND VGND VPWR VPWR sky130_fd_sc_hd__decap_3
X_087_ net34 net29 net11 net25 VGND VGND VPWR VPWR _028_ sky130_fd_sc_hd__and4bb_1
XFILLER_8_48 VGND VGND VPWR VPWR sky130_fd_sc_hd__fill_2
XFILLER_8_37 VGND VGND VPWR VPWR sky130_fd_sc_hd__decap_3
XFILLER_5_38 VGND VGND VPWR VPWR sky130_fd_sc_hd__decap_3
XTAP_TAPCELL_ROW_1_28 VGND VPWR sky130_fd_sc_hd__tapvpwrvgnd_1
XFILLER_0_60 VGND VGND VPWR VPWR sky130_fd_sc_hd__decap_3
XFILLER_0_71 VGND VGND VPWR VPWR sky130_fd_sc_hd__decap_3
XFILLER_9_3 VGND VGND VPWR VPWR sky130_fd_sc_hd__fill_2
X_086_ net34 net29 net5 net25 VGND VGND VPWR VPWR _027_ sky130_fd_sc_hd__and4b_1
XFILLER_8_16 VGND VGND VPWR VPWR sky130_fd_sc_hd__decap_3
XPHY_EDGE_ROW_1_Left_14 VGND VGND VPWR VPWR sky130_fd_sc_hd__decap_3
XFILLER_3_60 VGND VGND VPWR VPWR sky130_fd_sc_hd__decap_3
X_069_ net33 net28 net11 net24 VGND VGND VPWR VPWR _012_ sky130_fd_sc_hd__and4b_1
XPHY_EDGE_ROW_7_Right_7 VGND VGND VPWR VPWR sky130_fd_sc_hd__decap_3
XTAP_TAPCELL_ROW_11_38 VGND VPWR sky130_fd_sc_hd__tapvpwrvgnd_1
X_085_ net25 net10 net29 net34 VGND VGND VPWR VPWR _026_ sky130_fd_sc_hd__o211a_1
XFILLER_5_18 VGND VGND VPWR VPWR sky130_fd_sc_hd__decap_3
X_068_ net26 net10 net22 net31 VGND VGND VPWR VPWR _011_ sky130_fd_sc_hd__and4b_1
XFILLER_12_60 VGND VGND VPWR VPWR sky130_fd_sc_hd__decap_3
X_084_ net25 net34 net29 net9 VGND VGND VPWR VPWR _025_ sky130_fd_sc_hd__and4bb_1
XFILLER_8_29 VGND VGND VPWR VPWR sky130_fd_sc_hd__fill_1
X_067_ net11 _000_ _004_ _010_ VGND VGND VPWR VPWR net12 sky130_fd_sc_hd__o22a_1
XFILLER_0_63 VGND VGND VPWR VPWR sky130_fd_sc_hd__fill_2
XFILLER_0_74 VGND VGND VPWR VPWR sky130_fd_sc_hd__decap_3
X_119_ net10 _000_ _051_ _055_ VGND VGND VPWR VPWR net19 sky130_fd_sc_hd__o22a_1
XFILLER_12_72 VGND VGND VPWR VPWR sky130_fd_sc_hd__decap_3
XFILLER_12_50 VGND VGND VPWR VPWR sky130_fd_sc_hd__decap_3
XFILLER_8_19 VGND VGND VPWR VPWR sky130_fd_sc_hd__decap_3
X_083_ net7 _001_ net20 net8 VGND VGND VPWR VPWR _024_ sky130_fd_sc_hd__a22o_1
XPHY_EDGE_ROW_5_Left_18 VGND VGND VPWR VPWR sky130_fd_sc_hd__decap_3
X_118_ net11 _001_ _052_ _053_ _054_ VGND VGND VPWR VPWR _055_ sky130_fd_sc_hd__a2111o_1
XPHY_EDGE_ROW_8_Left_21 VGND VGND VPWR VPWR sky130_fd_sc_hd__decap_3
X_066_ net5 _008_ _009_ _006_ _007_ VGND VGND VPWR VPWR _010_ sky130_fd_sc_hd__a2111o_1
XFILLER_6_52 VGND VGND VPWR VPWR sky130_fd_sc_hd__decap_3
XFILLER_3_20 VGND VGND VPWR VPWR sky130_fd_sc_hd__decap_3
XTAP_TAPCELL_ROW_12_40 VGND VPWR sky130_fd_sc_hd__tapvpwrvgnd_1
X_082_ net4 _005_ VGND VGND VPWR VPWR _023_ sky130_fd_sc_hd__and2_1
X_065_ net33 net28 net10 net24 VGND VGND VPWR VPWR _009_ sky130_fd_sc_hd__and4b_1
X_117_ net23 net32 net30 net5 VGND VGND VPWR VPWR _054_ sky130_fd_sc_hd__and4bb_1
XFILLER_9_41 VGND VGND VPWR VPWR sky130_fd_sc_hd__decap_3
XFILLER_12_63 VGND VGND VPWR VPWR sky130_fd_sc_hd__decap_3
XFILLER_12_41 VGND VGND VPWR VPWR sky130_fd_sc_hd__decap_3
X_081_ net5 _000_ _021_ _022_ VGND VGND VPWR VPWR net14 sky130_fd_sc_hd__o22a_1
XFILLER_3_76 VGND VGND VPWR VPWR sky130_fd_sc_hd__fill_2
XTAP_TAPCELL_ROW_5_32 VGND VPWR sky130_fd_sc_hd__tapvpwrvgnd_1
X_064_ net24 net28 net33 VGND VGND VPWR VPWR _008_ sky130_fd_sc_hd__nor3b_1
XFILLER_0_77 VGND VGND VPWR VPWR sky130_fd_sc_hd__fill_1
X_116_ net23 net6 net27 net32 VGND VGND VPWR VPWR _053_ sky130_fd_sc_hd__o211a_1
XPHY_EDGE_ROW_2_Right_2 VGND VGND VPWR VPWR sky130_fd_sc_hd__decap_3
XFILLER_3_11 VGND VGND VPWR VPWR sky130_fd_sc_hd__fill_2
XFILLER_12_75 VGND VGND VPWR VPWR sky130_fd_sc_hd__decap_3
XFILLER_12_53 VGND VGND VPWR VPWR sky130_fd_sc_hd__decap_3
X_063_ net24 net7 net29 net33 VGND VGND VPWR VPWR _007_ sky130_fd_sc_hd__o211a_1
X_080_ net7 _008_ _018_ _019_ _020_ VGND VGND VPWR VPWR _022_ sky130_fd_sc_hd__a2111o_1
XFILLER_5_3 VGND VGND VPWR VPWR sky130_fd_sc_hd__fill_1
X_115_ net1 net30 net7 net3 VGND VGND VPWR VPWR _052_ sky130_fd_sc_hd__and4bb_1
XFILLER_9_54 VGND VGND VPWR VPWR sky130_fd_sc_hd__fill_2
XFILLER_0_23 VGND VGND VPWR VPWR sky130_fd_sc_hd__fill_1
.ends
