* NGSPICE file created from alu.ext - technology: sky130A

* Black-box entry subcircuit for sky130_fd_sc_hd__decap_3 abstract view
.subckt sky130_fd_sc_hd__decap_3 VGND VNB VPB VPWR
.ends

* Black-box entry subcircuit for sky130_fd_sc_hd__a211o_1 abstract view
.subckt sky130_fd_sc_hd__a211o_1 A1 A2 B1 C1 VGND VNB VPB VPWR X
.ends

* Black-box entry subcircuit for sky130_fd_sc_hd__nand2b_1 abstract view
.subckt sky130_fd_sc_hd__nand2b_1 A_N B VGND VNB VPB VPWR Y
.ends

* Black-box entry subcircuit for sky130_fd_sc_hd__fill_1 abstract view
.subckt sky130_fd_sc_hd__fill_1 VGND VNB VPB VPWR
.ends

* Black-box entry subcircuit for sky130_fd_sc_hd__tapvpwrvgnd_1 abstract view
.subckt sky130_fd_sc_hd__tapvpwrvgnd_1 VGND VPWR
.ends

* Black-box entry subcircuit for sky130_fd_sc_hd__buf_2 abstract view
.subckt sky130_fd_sc_hd__buf_2 A VGND VNB VPB VPWR X
.ends

* Black-box entry subcircuit for sky130_fd_sc_hd__fill_2 abstract view
.subckt sky130_fd_sc_hd__fill_2 VGND VNB VPB VPWR
.ends

* Black-box entry subcircuit for sky130_fd_sc_hd__or2_1 abstract view
.subckt sky130_fd_sc_hd__or2_1 A B VGND VNB VPB VPWR X
.ends

* Black-box entry subcircuit for sky130_fd_sc_hd__o2bb2a_1 abstract view
.subckt sky130_fd_sc_hd__o2bb2a_1 A1_N A2_N B1 B2 VGND VNB VPB VPWR X
.ends

* Black-box entry subcircuit for sky130_fd_sc_hd__nor2_1 abstract view
.subckt sky130_fd_sc_hd__nor2_1 A B VGND VNB VPB VPWR Y
.ends

* Black-box entry subcircuit for sky130_fd_sc_hd__o21ba_1 abstract view
.subckt sky130_fd_sc_hd__o21ba_1 A1 A2 B1_N VGND VNB VPB VPWR X
.ends

* Black-box entry subcircuit for sky130_fd_sc_hd__o22a_1 abstract view
.subckt sky130_fd_sc_hd__o22a_1 A1 A2 B1 B2 VGND VNB VPB VPWR X
.ends

* Black-box entry subcircuit for sky130_fd_sc_hd__o32a_1 abstract view
.subckt sky130_fd_sc_hd__o32a_1 A1 A2 A3 B1 B2 VGND VNB VPB VPWR X
.ends

* Black-box entry subcircuit for sky130_fd_sc_hd__a31o_1 abstract view
.subckt sky130_fd_sc_hd__a31o_1 A1 A2 A3 B1 VGND VNB VPB VPWR X
.ends

* Black-box entry subcircuit for sky130_fd_sc_hd__or4_1 abstract view
.subckt sky130_fd_sc_hd__or4_1 A B C D VGND VNB VPB VPWR X
.ends

* Black-box entry subcircuit for sky130_fd_sc_hd__a21o_1 abstract view
.subckt sky130_fd_sc_hd__a21o_1 A1 A2 B1 VGND VNB VPB VPWR X
.ends

* Black-box entry subcircuit for sky130_fd_sc_hd__a22o_1 abstract view
.subckt sky130_fd_sc_hd__a22o_1 A1 A2 B1 B2 VGND VNB VPB VPWR X
.ends

* Black-box entry subcircuit for sky130_fd_sc_hd__a221o_1 abstract view
.subckt sky130_fd_sc_hd__a221o_1 A1 A2 B1 B2 C1 VGND VNB VPB VPWR X
.ends

* Black-box entry subcircuit for sky130_fd_sc_hd__and2_2 abstract view
.subckt sky130_fd_sc_hd__and2_2 A B VGND VNB VPB VPWR X
.ends

* Black-box entry subcircuit for sky130_fd_sc_hd__o21a_1 abstract view
.subckt sky130_fd_sc_hd__o21a_1 A1 A2 B1 VGND VNB VPB VPWR X
.ends

* Black-box entry subcircuit for sky130_fd_sc_hd__o211a_1 abstract view
.subckt sky130_fd_sc_hd__o211a_1 A1 A2 B1 C1 VGND VNB VPB VPWR X
.ends

* Black-box entry subcircuit for sky130_fd_sc_hd__and2b_1 abstract view
.subckt sky130_fd_sc_hd__and2b_1 A_N B VGND VNB VPB VPWR X
.ends

* Black-box entry subcircuit for sky130_fd_sc_hd__dlymetal6s2s_1 abstract view
.subckt sky130_fd_sc_hd__dlymetal6s2s_1 A VGND VNB VPB VPWR X
.ends

* Black-box entry subcircuit for sky130_fd_sc_hd__and2_1 abstract view
.subckt sky130_fd_sc_hd__and2_1 A B VGND VNB VPB VPWR X
.ends

* Black-box entry subcircuit for sky130_fd_sc_hd__xnor2_1 abstract view
.subckt sky130_fd_sc_hd__xnor2_1 A B VGND VNB VPB VPWR Y
.ends

* Black-box entry subcircuit for sky130_fd_sc_hd__clkbuf_2 abstract view
.subckt sky130_fd_sc_hd__clkbuf_2 A VGND VNB VPB VPWR X
.ends

* Black-box entry subcircuit for sky130_fd_sc_hd__nor3b_4 abstract view
.subckt sky130_fd_sc_hd__nor3b_4 A B C_N VGND VNB VPB VPWR Y
.ends

* Black-box entry subcircuit for sky130_fd_sc_hd__or3b_2 abstract view
.subckt sky130_fd_sc_hd__or3b_2 A B C_N VGND VNB VPB VPWR X
.ends

* Black-box entry subcircuit for sky130_fd_sc_hd__buf_1 abstract view
.subckt sky130_fd_sc_hd__buf_1 A VGND VNB VPB VPWR X
.ends

* Black-box entry subcircuit for sky130_fd_sc_hd__and3b_1 abstract view
.subckt sky130_fd_sc_hd__and3b_1 A_N B C VGND VNB VPB VPWR X
.ends

* Black-box entry subcircuit for sky130_fd_sc_hd__nor3b_1 abstract view
.subckt sky130_fd_sc_hd__nor3b_1 A B C_N VGND VNB VPB VPWR Y
.ends

* Black-box entry subcircuit for sky130_fd_sc_hd__a21oi_1 abstract view
.subckt sky130_fd_sc_hd__a21oi_1 A1 A2 B1 VGND VNB VPB VPWR Y
.ends

* Black-box entry subcircuit for sky130_fd_sc_hd__clkbuf_1 abstract view
.subckt sky130_fd_sc_hd__clkbuf_1 A VGND VNB VPB VPWR X
.ends

* Black-box entry subcircuit for sky130_fd_sc_hd__a21bo_1 abstract view
.subckt sky130_fd_sc_hd__a21bo_1 A1 A2 B1_N VGND VNB VPB VPWR X
.ends

* Black-box entry subcircuit for sky130_fd_sc_hd__or3_4 abstract view
.subckt sky130_fd_sc_hd__or3_4 A B C VGND VNB VPB VPWR X
.ends

* Black-box entry subcircuit for sky130_fd_sc_hd__mux2_1 abstract view
.subckt sky130_fd_sc_hd__mux2_1 A0 A1 S VGND VNB VPB VPWR X
.ends

* Black-box entry subcircuit for sky130_fd_sc_hd__nor3_4 abstract view
.subckt sky130_fd_sc_hd__nor3_4 A B C VGND VNB VPB VPWR Y
.ends

* Black-box entry subcircuit for sky130_fd_sc_hd__a41o_1 abstract view
.subckt sky130_fd_sc_hd__a41o_1 A1 A2 A3 A4 B1 VGND VNB VPB VPWR X
.ends

* Black-box entry subcircuit for sky130_fd_sc_hd__nand2_1 abstract view
.subckt sky130_fd_sc_hd__nand2_1 A B VGND VNB VPB VPWR Y
.ends

* Black-box entry subcircuit for sky130_fd_sc_hd__and3b_2 abstract view
.subckt sky130_fd_sc_hd__and3b_2 A_N B C VGND VNB VPB VPWR X
.ends

* Black-box entry subcircuit for sky130_fd_sc_hd__nand3_1 abstract view
.subckt sky130_fd_sc_hd__nand3_1 A B C VGND VNB VPB VPWR Y
.ends

* Black-box entry subcircuit for sky130_fd_sc_hd__o211ai_1 abstract view
.subckt sky130_fd_sc_hd__o211ai_1 A1 A2 B1 C1 VGND VNB VPB VPWR Y
.ends

* Black-box entry subcircuit for sky130_fd_sc_hd__nor3_1 abstract view
.subckt sky130_fd_sc_hd__nor3_1 A B C VGND VNB VPB VPWR Y
.ends

* Black-box entry subcircuit for sky130_fd_sc_hd__nand2_2 abstract view
.subckt sky130_fd_sc_hd__nand2_2 A B VGND VNB VPB VPWR Y
.ends

* Black-box entry subcircuit for sky130_fd_sc_hd__and3_2 abstract view
.subckt sky130_fd_sc_hd__and3_2 A B C VGND VNB VPB VPWR X
.ends

.subckt alu VGND VPWR data1[0] data1[1] data1[2] data1[3] data1[4] data1[5] data1[6]
+ data1[7] data2[0] data2[1] data2[2] data2[3] data2[4] data2[5] data2[6] data2[7]
+ op[0] op[1] op[2] res[0] res[1] res[2] res[3] res[4] res[5] res[6] res[7] z
XFILLER_3_45 VGND VGND VPWR VPWR sky130_fd_sc_hd__decap_3
XFILLER_3_12 VGND VGND VPWR VPWR sky130_fd_sc_hd__decap_3
XFILLER_12_32 VGND VGND VPWR VPWR sky130_fd_sc_hd__decap_3
X_200_ net30 _119_ _001_ _002_ VGND VGND VPWR VPWR _003_ sky130_fd_sc_hd__a211o_1
X_131_ _060_ _061_ VGND VGND VPWR VPWR _062_ sky130_fd_sc_hd__nand2b_1
XFILLER_0_57 VGND VGND VPWR VPWR sky130_fd_sc_hd__decap_3
XFILLER_17_9 VGND VGND VPWR VPWR sky130_fd_sc_hd__fill_1
XTAP_TAPCELL_ROW_5_45 VGND VPWR sky130_fd_sc_hd__tapvpwrvgnd_1
XFILLER_13_3 VGND VGND VPWR VPWR sky130_fd_sc_hd__decap_3
XFILLER_6_34 VGND VGND VPWR VPWR sky130_fd_sc_hd__decap_3
Xoutput20 net20 VGND VGND VPWR VPWR res[0] sky130_fd_sc_hd__buf_2
XFILLER_3_57 VGND VGND VPWR VPWR sky130_fd_sc_hd__fill_2
XFILLER_3_24 VGND VGND VPWR VPWR sky130_fd_sc_hd__decap_3
XTAP_TAPCELL_ROW_12_55 VGND VPWR sky130_fd_sc_hd__tapvpwrvgnd_1
XFILLER_12_22 VGND VGND VPWR VPWR sky130_fd_sc_hd__decap_3
XFILLER_12_44 VGND VGND VPWR VPWR sky130_fd_sc_hd__decap_3
XFILLER_12_66 VGND VGND VPWR VPWR sky130_fd_sc_hd__decap_3
X_130_ net42 net6 VGND VGND VPWR VPWR _061_ sky130_fd_sc_hd__or2_1
XPHY_EDGE_ROW_12_Right_12 VGND VGND VPWR VPWR sky130_fd_sc_hd__decap_3
XFILLER_0_47 VGND VGND VPWR VPWR sky130_fd_sc_hd__decap_3
XFILLER_0_69 VGND VGND VPWR VPWR sky130_fd_sc_hd__decap_3
X_259_ _059_ _101_ net24 _055_ VGND VGND VPWR VPWR _056_ sky130_fd_sc_hd__o2bb2a_1
XFILLER_2_100 VGND VGND VPWR VPWR sky130_fd_sc_hd__fill_1
XPHY_EDGE_ROW_8_Left_26 VGND VGND VPWR VPWR sky130_fd_sc_hd__decap_3
XFILLER_6_79 VGND VGND VPWR VPWR sky130_fd_sc_hd__decap_3
XFILLER_6_46 VGND VGND VPWR VPWR sky130_fd_sc_hd__decap_3
XPHY_EDGE_ROW_6_Right_6 VGND VGND VPWR VPWR sky130_fd_sc_hd__decap_3
XFILLER_15_88 VGND VGND VPWR VPWR sky130_fd_sc_hd__fill_1
Xoutput21 net21 VGND VGND VPWR VPWR res[1] sky130_fd_sc_hd__buf_2
XFILLER_12_56 VGND VGND VPWR VPWR sky130_fd_sc_hd__decap_3
XTAP_TAPCELL_ROW_12_56 VGND VPWR sky130_fd_sc_hd__tapvpwrvgnd_1
XFILLER_5_6 VGND VGND VPWR VPWR sky130_fd_sc_hd__decap_3
XFILLER_0_15 VGND VGND VPWR VPWR sky130_fd_sc_hd__decap_3
XFILLER_3_3 VGND VGND VPWR VPWR sky130_fd_sc_hd__decap_3
X_258_ net23 _054_ VGND VGND VPWR VPWR _055_ sky130_fd_sc_hd__nor2_1
X_189_ net38 _058_ VGND VGND VPWR VPWR _118_ sky130_fd_sc_hd__or2_1
XFILLER_9_68 VGND VGND VPWR VPWR sky130_fd_sc_hd__decap_3
XFILLER_1_91 VGND VGND VPWR VPWR sky130_fd_sc_hd__decap_3
XFILLER_15_12 VGND VGND VPWR VPWR sky130_fd_sc_hd__fill_2
XFILLER_15_23 VGND VGND VPWR VPWR sky130_fd_sc_hd__decap_3
Xoutput22 net22 VGND VGND VPWR VPWR res[2] sky130_fd_sc_hd__buf_2
XFILLER_3_15 VGND VGND VPWR VPWR sky130_fd_sc_hd__decap_3
XFILLER_12_35 VGND VGND VPWR VPWR sky130_fd_sc_hd__decap_3
XFILLER_0_27 VGND VGND VPWR VPWR sky130_fd_sc_hd__fill_1
X_257_ net21 net20 net22 VGND VGND VPWR VPWR _054_ sky130_fd_sc_hd__o21ba_1
X_188_ net40 _058_ _114_ _117_ VGND VGND VPWR VPWR net26 sky130_fd_sc_hd__o22a_1
XFILLER_1_70 VGND VGND VPWR VPWR sky130_fd_sc_hd__decap_3
XFILLER_6_37 VGND VGND VPWR VPWR sky130_fd_sc_hd__fill_2
XFILLER_13_6 VGND VGND VPWR VPWR sky130_fd_sc_hd__decap_3
XFILLER_15_57 VGND VGND VPWR VPWR sky130_fd_sc_hd__fill_2
Xoutput23 net23 VGND VGND VPWR VPWR res[3] sky130_fd_sc_hd__buf_2
XFILLER_3_27 VGND VGND VPWR VPWR sky130_fd_sc_hd__decap_3
XFILLER_12_25 VGND VGND VPWR VPWR sky130_fd_sc_hd__decap_3
XFILLER_12_47 VGND VGND VPWR VPWR sky130_fd_sc_hd__decap_3
XFILLER_12_69 VGND VGND VPWR VPWR sky130_fd_sc_hd__fill_1
X_256_ _045_ _051_ _053_ _058_ net11 VGND VGND VPWR VPWR net22 sky130_fd_sc_hd__o32a_1
X_187_ _078_ _106_ _107_ _116_ VGND VGND VPWR VPWR _117_ sky130_fd_sc_hd__a31o_1
XFILLER_9_48 VGND VGND VPWR VPWR sky130_fd_sc_hd__fill_1
X_239_ _034_ _035_ _036_ _037_ VGND VGND VPWR VPWR _038_ sky130_fd_sc_hd__or4_1
XFILLER_1_82 VGND VGND VPWR VPWR sky130_fd_sc_hd__decap_3
XFILLER_10_91 VGND VGND VPWR VPWR sky130_fd_sc_hd__fill_1
XFILLER_6_49 VGND VGND VPWR VPWR sky130_fd_sc_hd__decap_3
Xoutput24 net24 VGND VGND VPWR VPWR res[4] sky130_fd_sc_hd__buf_2
XFILLER_7_70 VGND VGND VPWR VPWR sky130_fd_sc_hd__decap_3
XFILLER_12_59 VGND VGND VPWR VPWR sky130_fd_sc_hd__fill_1
XTAP_TAPCELL_ROW_8_49 VGND VPWR sky130_fd_sc_hd__tapvpwrvgnd_1
XFILLER_5_9 VGND VGND VPWR VPWR sky130_fd_sc_hd__decap_3
XFILLER_4_93 VGND VGND VPWR VPWR sky130_fd_sc_hd__fill_1
XFILLER_4_82 VGND VGND VPWR VPWR sky130_fd_sc_hd__fill_2
XFILLER_4_71 VGND VGND VPWR VPWR sky130_fd_sc_hd__decap_3
XFILLER_0_18 VGND VGND VPWR VPWR sky130_fd_sc_hd__decap_3
XFILLER_0_29 VGND VGND VPWR VPWR sky130_fd_sc_hd__decap_3
X_255_ _074_ _099_ _052_ VGND VGND VPWR VPWR _053_ sky130_fd_sc_hd__a21o_1
X_186_ _099_ _104_ _115_ VGND VGND VPWR VPWR _116_ sky130_fd_sc_hd__a21o_1
XFILLER_9_27 VGND VGND VPWR VPWR sky130_fd_sc_hd__decap_3
XFILLER_3_6 VGND VGND VPWR VPWR sky130_fd_sc_hd__decap_3
XFILLER_1_3 VGND VGND VPWR VPWR sky130_fd_sc_hd__decap_3
X_238_ net5 net33 _110_ net35 VGND VGND VPWR VPWR _037_ sky130_fd_sc_hd__a22o_1
X_169_ _060_ net30 _099_ _061_ _057_ VGND VGND VPWR VPWR _100_ sky130_fd_sc_hd__a221o_1
XFILLER_1_94 VGND VGND VPWR VPWR sky130_fd_sc_hd__decap_3
XFILLER_1_61 VGND VGND VPWR VPWR sky130_fd_sc_hd__decap_3
XFILLER_15_26 VGND VGND VPWR VPWR sky130_fd_sc_hd__decap_3
Xoutput25 net25 VGND VGND VPWR VPWR res[5] sky130_fd_sc_hd__buf_2
XPHY_EDGE_ROW_15_Left_33 VGND VGND VPWR VPWR sky130_fd_sc_hd__decap_3
XFILLER_3_18 VGND VGND VPWR VPWR sky130_fd_sc_hd__decap_3
XFILLER_12_38 VGND VGND VPWR VPWR sky130_fd_sc_hd__decap_3
XPHY_EDGE_ROW_0_Left_18 VGND VGND VPWR VPWR sky130_fd_sc_hd__decap_3
X_254_ net3 net11 net30 _057_ VGND VGND VPWR VPWR _052_ sky130_fd_sc_hd__a31o_1
X_185_ net40 net34 net30 _057_ VGND VGND VPWR VPWR _115_ sky130_fd_sc_hd__a31o_1
XPHY_EDGE_ROW_3_Left_21 VGND VGND VPWR VPWR sky130_fd_sc_hd__decap_3
X_237_ net4 _083_ _087_ net6 _084_ VGND VGND VPWR VPWR _036_ sky130_fd_sc_hd__a221o_1
X_168_ net17 net30 VGND VGND VPWR VPWR _099_ sky130_fd_sc_hd__and2_2
XFILLER_1_73 VGND VGND VPWR VPWR sky130_fd_sc_hd__decap_3
XFILLER_10_60 VGND VGND VPWR VPWR sky130_fd_sc_hd__decap_3
XFILLER_16_104 VGND VGND VPWR VPWR sky130_fd_sc_hd__fill_1
Xoutput26 net26 VGND VGND VPWR VPWR res[6] sky130_fd_sc_hd__buf_2
XPHY_EDGE_ROW_1_Right_1 VGND VGND VPWR VPWR sky130_fd_sc_hd__decap_3
XFILLER_8_100 VGND VGND VPWR VPWR sky130_fd_sc_hd__decap_3
XFILLER_13_60 VGND VGND VPWR VPWR sky130_fd_sc_hd__decap_3
XFILLER_13_82 VGND VGND VPWR VPWR sky130_fd_sc_hd__decap_3
X_253_ _047_ _049_ _050_ VGND VGND VPWR VPWR _051_ sky130_fd_sc_hd__o21a_1
X_184_ net6 _085_ _096_ _113_ VGND VGND VPWR VPWR _114_ sky130_fd_sc_hd__o211a_1
X_236_ net36 net31 _109_ net34 VGND VGND VPWR VPWR _035_ sky130_fd_sc_hd__a22o_1
X_167_ net19 net18 VGND VGND VPWR VPWR _098_ sky130_fd_sc_hd__and2b_1
XFILLER_1_85 VGND VGND VPWR VPWR sky130_fd_sc_hd__decap_3
XFILLER_1_41 VGND VGND VPWR VPWR sky130_fd_sc_hd__decap_3
XFILLER_1_30 VGND VGND VPWR VPWR sky130_fd_sc_hd__decap_3
X_219_ net35 _109_ _017_ _019_ VGND VGND VPWR VPWR _020_ sky130_fd_sc_hd__a211o_1
Xoutput27 net27 VGND VGND VPWR VPWR res[7] sky130_fd_sc_hd__buf_2
XPHY_EDGE_ROW_15_Right_15 VGND VGND VPWR VPWR sky130_fd_sc_hd__decap_3
XFILLER_12_29 VGND VGND VPWR VPWR sky130_fd_sc_hd__decap_3
XFILLER_4_74 VGND VGND VPWR VPWR sky130_fd_sc_hd__fill_1
XFILLER_4_52 VGND VGND VPWR VPWR sky130_fd_sc_hd__fill_1
XFILLER_3_9 VGND VGND VPWR VPWR sky130_fd_sc_hd__decap_3
X_252_ net2 _085_ _096_ VGND VGND VPWR VPWR _050_ sky130_fd_sc_hd__o21a_1
Xfanout40 net15 VGND VGND VPWR VPWR net40 sky130_fd_sc_hd__dlymetal6s2s_1
X_183_ net5 _109_ _111_ _112_ VGND VGND VPWR VPWR _113_ sky130_fd_sc_hd__a211o_1
XTAP_TAPCELL_ROW_9_51 VGND VPWR sky130_fd_sc_hd__tapvpwrvgnd_1
X_235_ net43 net32 VGND VGND VPWR VPWR _034_ sky130_fd_sc_hd__and2_1
XFILLER_1_6 VGND VGND VPWR VPWR sky130_fd_sc_hd__decap_3
X_166_ net5 _085_ _095_ _096_ VGND VGND VPWR VPWR _097_ sky130_fd_sc_hd__o211a_1
XFILLER_1_97 VGND VGND VPWR VPWR sky130_fd_sc_hd__decap_3
XFILLER_1_64 VGND VGND VPWR VPWR sky130_fd_sc_hd__decap_3
X_218_ net43 _082_ _087_ net36 _018_ VGND VGND VPWR VPWR _019_ sky130_fd_sc_hd__a221o_1
X_149_ _062_ _077_ VGND VGND VPWR VPWR _080_ sky130_fd_sc_hd__xnor2_1
XFILLER_15_29 VGND VGND VPWR VPWR sky130_fd_sc_hd__fill_2
Xoutput28 net28 VGND VGND VPWR VPWR z sky130_fd_sc_hd__buf_2
XTAP_TAPCELL_ROW_16_61 VGND VPWR sky130_fd_sc_hd__tapvpwrvgnd_1
XTAP_TAPCELL_ROW_3_42 VGND VPWR sky130_fd_sc_hd__tapvpwrvgnd_1
X_251_ net35 _088_ net31 net4 _048_ VGND VGND VPWR VPWR _049_ sky130_fd_sc_hd__a221o_1
Xfanout30 _098_ VGND VGND VPWR VPWR net30 sky130_fd_sc_hd__buf_2
Xfanout41 net42 VGND VGND VPWR VPWR net41 sky130_fd_sc_hd__clkbuf_2
X_182_ net34 net32 net29 net43 _108_ VGND VGND VPWR VPWR _112_ sky130_fd_sc_hd__a221o_1
XFILLER_1_21 VGND VGND VPWR VPWR sky130_fd_sc_hd__decap_3
X_234_ _026_ _031_ _033_ _058_ net12 VGND VGND VPWR VPWR net23 sky130_fd_sc_hd__o32a_1
X_165_ net18 net17 net19 VGND VGND VPWR VPWR _096_ sky130_fd_sc_hd__nor3b_4
XFILLER_1_76 VGND VGND VPWR VPWR sky130_fd_sc_hd__decap_3
XTAP_TAPCELL_ROW_10_52 VGND VPWR sky130_fd_sc_hd__tapvpwrvgnd_1
XPHY_EDGE_ROW_7_Left_25 VGND VGND VPWR VPWR sky130_fd_sc_hd__decap_3
XFILLER_10_41 VGND VGND VPWR VPWR sky130_fd_sc_hd__decap_3
XFILLER_10_63 VGND VGND VPWR VPWR sky130_fd_sc_hd__decap_3
XFILLER_10_85 VGND VGND VPWR VPWR sky130_fd_sc_hd__decap_3
X_217_ net5 _088_ net29 net34 VGND VGND VPWR VPWR _018_ sky130_fd_sc_hd__a22o_1
X_148_ net19 net18 net17 VGND VGND VPWR VPWR _079_ sky130_fd_sc_hd__or3b_2
XFILLER_7_20 VGND VGND VPWR VPWR sky130_fd_sc_hd__decap_3
XTAP_TAPCELL_ROW_16_62 VGND VPWR sky130_fd_sc_hd__tapvpwrvgnd_1
XPHY_EDGE_ROW_5_Right_5 VGND VGND VPWR VPWR sky130_fd_sc_hd__decap_3
XFILLER_16_51 VGND VGND VPWR VPWR sky130_fd_sc_hd__decap_3
XFILLER_8_103 VGND VGND VPWR VPWR sky130_fd_sc_hd__fill_2
XFILLER_4_21 VGND VGND VPWR VPWR sky130_fd_sc_hd__decap_3
XFILLER_13_63 VGND VGND VPWR VPWR sky130_fd_sc_hd__decap_3
XFILLER_13_85 VGND VGND VPWR VPWR sky130_fd_sc_hd__decap_3
X_250_ net8 _087_ net29 net5 VGND VGND VPWR VPWR _048_ sky130_fd_sc_hd__a22o_1
Xfanout42 net14 VGND VGND VPWR VPWR net42 sky130_fd_sc_hd__buf_1
X_181_ net39 _091_ net41 VGND VGND VPWR VPWR _111_ sky130_fd_sc_hd__and3b_1
X_233_ _066_ net30 _032_ VGND VGND VPWR VPWR _033_ sky130_fd_sc_hd__a21o_1
X_164_ net35 _087_ _092_ _094_ VGND VGND VPWR VPWR _095_ sky130_fd_sc_hd__a211o_1
XFILLER_1_88 VGND VGND VPWR VPWR sky130_fd_sc_hd__decap_3
XTAP_TAPCELL_ROW_10_53 VGND VPWR sky130_fd_sc_hd__tapvpwrvgnd_1
X_216_ _083_ _090_ _093_ net6 VGND VGND VPWR VPWR _017_ sky130_fd_sc_hd__a22o_1
X_147_ net19 net18 net17 VGND VGND VPWR VPWR _078_ sky130_fd_sc_hd__nor3b_1
XFILLER_7_32 VGND VGND VPWR VPWR sky130_fd_sc_hd__decap_3
XPHY_EDGE_ROW_11_Right_11 VGND VGND VPWR VPWR sky130_fd_sc_hd__decap_3
Xfanout43 net1 VGND VGND VPWR VPWR net43 sky130_fd_sc_hd__buf_2
X_180_ net41 net37 net40 VGND VGND VPWR VPWR _110_ sky130_fd_sc_hd__nor3b_1
XFILLER_1_9 VGND VGND VPWR VPWR sky130_fd_sc_hd__decap_3
XFILLER_1_12 VGND VGND VPWR VPWR sky130_fd_sc_hd__decap_3
X_232_ net17 _068_ _098_ _057_ VGND VGND VPWR VPWR _032_ sky130_fd_sc_hd__a31o_1
X_163_ net6 net32 net31 net34 _086_ VGND VGND VPWR VPWR _094_ sky130_fd_sc_hd__a221o_1
XFILLER_1_67 VGND VGND VPWR VPWR sky130_fd_sc_hd__decap_3
XFILLER_10_32 VGND VGND VPWR VPWR sky130_fd_sc_hd__decap_3
X_215_ _065_ _076_ _015_ VGND VGND VPWR VPWR _016_ sky130_fd_sc_hd__o21a_1
X_146_ _064_ _076_ _063_ VGND VGND VPWR VPWR _077_ sky130_fd_sc_hd__a21o_1
X_129_ net42 net6 VGND VGND VPWR VPWR _060_ sky130_fd_sc_hd__and2_1
XFILLER_4_12 VGND VGND VPWR VPWR sky130_fd_sc_hd__decap_3
XFILLER_13_54 VGND VGND VPWR VPWR sky130_fd_sc_hd__fill_2
XFILLER_13_76 VGND VGND VPWR VPWR sky130_fd_sc_hd__decap_3
XFILLER_1_100 VGND VGND VPWR VPWR sky130_fd_sc_hd__decap_3
X_231_ net35 _085_ _096_ _030_ VGND VGND VPWR VPWR _031_ sky130_fd_sc_hd__o211a_1
X_162_ net39 net37 net41 VGND VGND VPWR VPWR _093_ sky130_fd_sc_hd__nor3b_1
XFILLER_1_79 VGND VGND VPWR VPWR sky130_fd_sc_hd__decap_3
XFILLER_1_24 VGND VGND VPWR VPWR sky130_fd_sc_hd__decap_3
XFILLER_10_11 VGND VGND VPWR VPWR sky130_fd_sc_hd__fill_2
XFILLER_10_44 VGND VGND VPWR VPWR sky130_fd_sc_hd__decap_3
XFILLER_10_66 VGND VGND VPWR VPWR sky130_fd_sc_hd__decap_3
XFILLER_10_88 VGND VGND VPWR VPWR sky130_fd_sc_hd__decap_3
Xinput1 data1[0] VGND VGND VPWR VPWR net1 sky130_fd_sc_hd__buf_1
X_214_ _065_ _076_ _079_ VGND VGND VPWR VPWR _015_ sky130_fd_sc_hd__a21oi_1
X_145_ _068_ _075_ _066_ VGND VGND VPWR VPWR _076_ sky130_fd_sc_hd__a21o_1
X_128_ net42 _058_ VGND VGND VPWR VPWR _059_ sky130_fd_sc_hd__or2_1
XFILLER_7_67 VGND VGND VPWR VPWR sky130_fd_sc_hd__decap_3
XFILLER_7_12 VGND VGND VPWR VPWR sky130_fd_sc_hd__fill_1
XFILLER_16_54 VGND VGND VPWR VPWR sky130_fd_sc_hd__fill_2
XPHY_EDGE_ROW_9_Right_9 VGND VGND VPWR VPWR sky130_fd_sc_hd__decap_3
XFILLER_4_68 VGND VGND VPWR VPWR sky130_fd_sc_hd__decap_3
XFILLER_4_24 VGND VGND VPWR VPWR sky130_fd_sc_hd__decap_3
XFILLER_13_66 VGND VGND VPWR VPWR sky130_fd_sc_hd__decap_3
XFILLER_13_88 VGND VGND VPWR VPWR sky130_fd_sc_hd__decap_3
Xfanout34 net7 VGND VGND VPWR VPWR net34 sky130_fd_sc_hd__buf_2
XTAP_TAPCELL_ROW_0_36 VGND VPWR sky130_fd_sc_hd__tapvpwrvgnd_1
X_230_ net43 _087_ _028_ _029_ VGND VGND VPWR VPWR _030_ sky130_fd_sc_hd__a211o_1
X_161_ net42 net39 _091_ VGND VGND VPWR VPWR _092_ sky130_fd_sc_hd__and3b_1
Xinput2 data1[1] VGND VGND VPWR VPWR net2 sky130_fd_sc_hd__clkbuf_1
X_213_ _010_ _013_ _014_ _058_ net10 VGND VGND VPWR VPWR net21 sky130_fd_sc_hd__o32a_1
X_144_ _073_ _074_ _069_ VGND VGND VPWR VPWR _075_ sky130_fd_sc_hd__a21bo_1
XTAP_TAPCELL_ROW_6_46 VGND VPWR sky130_fd_sc_hd__tapvpwrvgnd_1
XPHY_EDGE_ROW_11_Left_29 VGND VGND VPWR VPWR sky130_fd_sc_hd__decap_3
Xmax_cap31 _093_ VGND VGND VPWR VPWR net31 sky130_fd_sc_hd__clkbuf_2
XFILLER_16_3 VGND VGND VPWR VPWR sky130_fd_sc_hd__decap_3
X_127_ net19 net18 net17 VGND VGND VPWR VPWR _058_ sky130_fd_sc_hd__or3_4
XFILLER_7_57 VGND VGND VPWR VPWR sky130_fd_sc_hd__fill_2
XFILLER_7_46 VGND VGND VPWR VPWR sky130_fd_sc_hd__fill_2
XFILLER_7_35 VGND VGND VPWR VPWR sky130_fd_sc_hd__decap_3
XFILLER_12_103 VGND VGND VPWR VPWR sky130_fd_sc_hd__fill_2
XPHY_EDGE_ROW_14_Left_32 VGND VGND VPWR VPWR sky130_fd_sc_hd__decap_3
Xfanout35 net3 VGND VGND VPWR VPWR net35 sky130_fd_sc_hd__buf_2
XTAP_TAPCELL_ROW_0_37 VGND VPWR sky130_fd_sc_hd__tapvpwrvgnd_1
XFILLER_1_15 VGND VGND VPWR VPWR sky130_fd_sc_hd__decap_3
X_160_ net8 net4 net37 VGND VGND VPWR VPWR _091_ sky130_fd_sc_hd__mux2_1
Xinput3 data1[2] VGND VGND VPWR VPWR net3 sky130_fd_sc_hd__clkbuf_1
XFILLER_10_35 VGND VGND VPWR VPWR sky130_fd_sc_hd__decap_3
X_212_ _070_ net30 _099_ _072_ _057_ VGND VGND VPWR VPWR _014_ sky130_fd_sc_hd__a221o_1
X_143_ net35 net11 VGND VGND VPWR VPWR _074_ sky130_fd_sc_hd__or2_1
XTAP_TAPCELL_ROW_6_47 VGND VPWR sky130_fd_sc_hd__tapvpwrvgnd_1
XPHY_EDGE_ROW_2_Left_20 VGND VGND VPWR VPWR sky130_fd_sc_hd__decap_3
XFILLER_2_91 VGND VGND VPWR VPWR sky130_fd_sc_hd__decap_3
Xmax_cap32 _088_ VGND VGND VPWR VPWR net32 sky130_fd_sc_hd__clkbuf_2
X_126_ net19 net18 net17 VGND VGND VPWR VPWR _057_ sky130_fd_sc_hd__nor3_4
XPHY_EDGE_ROW_0_Right_0 VGND VGND VPWR VPWR sky130_fd_sc_hd__decap_3
XFILLER_4_15 VGND VGND VPWR VPWR sky130_fd_sc_hd__decap_3
XFILLER_13_24 VGND VGND VPWR VPWR sky130_fd_sc_hd__decap_3
XFILLER_13_57 VGND VGND VPWR VPWR sky130_fd_sc_hd__decap_3
XFILLER_13_79 VGND VGND VPWR VPWR sky130_fd_sc_hd__decap_3
XFILLER_1_103 VGND VGND VPWR VPWR sky130_fd_sc_hd__fill_2
Xfanout36 net2 VGND VGND VPWR VPWR net36 sky130_fd_sc_hd__buf_2
XTAP_TAPCELL_ROW_13_57 VGND VPWR sky130_fd_sc_hd__tapvpwrvgnd_1
XTAP_TAPCELL_ROW_0_38 VGND VPWR sky130_fd_sc_hd__tapvpwrvgnd_1
XFILLER_1_27 VGND VGND VPWR VPWR sky130_fd_sc_hd__decap_3
Xinput4 data1[3] VGND VGND VPWR VPWR net4 sky130_fd_sc_hd__buf_2
XFILLER_10_69 VGND VGND VPWR VPWR sky130_fd_sc_hd__fill_2
X_211_ _012_ _011_ VGND VGND VPWR VPWR _013_ sky130_fd_sc_hd__and2b_1
X_142_ net43 net9 _072_ _070_ VGND VGND VPWR VPWR _073_ sky130_fd_sc_hd__a31o_1
Xmax_cap33 _082_ VGND VGND VPWR VPWR net33 sky130_fd_sc_hd__clkbuf_2
XFILLER_7_26 VGND VGND VPWR VPWR sky130_fd_sc_hd__decap_3
XFILLER_4_27 VGND VGND VPWR VPWR sky130_fd_sc_hd__fill_1
Xfanout37 net38 VGND VGND VPWR VPWR net37 sky130_fd_sc_hd__clkbuf_2
Xinput5 data1[4] VGND VGND VPWR VPWR net5 sky130_fd_sc_hd__buf_2
XFILLER_10_26 VGND VGND VPWR VPWR sky130_fd_sc_hd__fill_2
X_210_ net1 net9 _071_ _072_ _079_ VGND VGND VPWR VPWR _012_ sky130_fd_sc_hd__a41o_1
X_141_ net36 net10 VGND VGND VPWR VPWR _072_ sky130_fd_sc_hd__or2_1
XFILLER_2_82 VGND VGND VPWR VPWR sky130_fd_sc_hd__fill_2
XFILLER_2_71 VGND VGND VPWR VPWR sky130_fd_sc_hd__decap_3
XFILLER_16_25 VGND VGND VPWR VPWR sky130_fd_sc_hd__decap_3
XFILLER_14_3 VGND VGND VPWR VPWR sky130_fd_sc_hd__decap_3
XFILLER_8_81 VGND VGND VPWR VPWR sky130_fd_sc_hd__decap_3
Xfanout38 net16 VGND VGND VPWR VPWR net38 sky130_fd_sc_hd__buf_1
XFILLER_5_71 VGND VGND VPWR VPWR sky130_fd_sc_hd__decap_3
XFILLER_14_91 VGND VGND VPWR VPWR sky130_fd_sc_hd__decap_3
XFILLER_1_18 VGND VGND VPWR VPWR sky130_fd_sc_hd__decap_3
XFILLER_10_38 VGND VGND VPWR VPWR sky130_fd_sc_hd__decap_3
Xinput6 data1[5] VGND VGND VPWR VPWR net6 sky130_fd_sc_hd__buf_2
X_140_ net36 net10 VGND VGND VPWR VPWR _071_ sky130_fd_sc_hd__nand2_1
XPHY_EDGE_ROW_14_Right_14 VGND VGND VPWR VPWR sky130_fd_sc_hd__decap_3
XFILLER_2_94 VGND VGND VPWR VPWR sky130_fd_sc_hd__decap_3
XPHY_EDGE_ROW_6_Left_24 VGND VGND VPWR VPWR sky130_fd_sc_hd__decap_3
XFILLER_11_81 VGND VGND VPWR VPWR sky130_fd_sc_hd__decap_3
XFILLER_16_48 VGND VGND VPWR VPWR sky130_fd_sc_hd__decap_3
XPHY_EDGE_ROW_4_Right_4 VGND VGND VPWR VPWR sky130_fd_sc_hd__decap_3
XFILLER_8_60 VGND VGND VPWR VPWR sky130_fd_sc_hd__decap_3
XFILLER_4_29 VGND VGND VPWR VPWR sky130_fd_sc_hd__decap_3
XFILLER_4_18 VGND VGND VPWR VPWR sky130_fd_sc_hd__decap_3
XFILLER_13_27 VGND VGND VPWR VPWR sky130_fd_sc_hd__fill_2
Xfanout39 net40 VGND VGND VPWR VPWR net39 sky130_fd_sc_hd__clkbuf_2
XFILLER_5_50 VGND VGND VPWR VPWR sky130_fd_sc_hd__decap_3
XFILLER_14_81 VGND VGND VPWR VPWR sky130_fd_sc_hd__decap_3
XFILLER_6_6 VGND VGND VPWR VPWR sky130_fd_sc_hd__decap_3
Xinput7 data1[6] VGND VGND VPWR VPWR net7 sky130_fd_sc_hd__clkbuf_1
XFILLER_4_3 VGND VGND VPWR VPWR sky130_fd_sc_hd__decap_3
X_199_ _090_ _099_ _120_ _057_ VGND VGND VPWR VPWR _002_ sky130_fd_sc_hd__a31o_1
XFILLER_11_71 VGND VGND VPWR VPWR sky130_fd_sc_hd__fill_2
XFILLER_7_29 VGND VGND VPWR VPWR sky130_fd_sc_hd__decap_3
Xinput10 data2[1] VGND VGND VPWR VPWR net10 sky130_fd_sc_hd__buf_1
XFILLER_8_72 VGND VGND VPWR VPWR sky130_fd_sc_hd__decap_3
Xinput8 data1[7] VGND VGND VPWR VPWR net8 sky130_fd_sc_hd__clkbuf_2
XFILLER_10_29 VGND VGND VPWR VPWR sky130_fd_sc_hd__decap_3
X_198_ _123_ _125_ _000_ _096_ VGND VGND VPWR VPWR _001_ sky130_fd_sc_hd__o211a_1
XFILLER_2_85 VGND VGND VPWR VPWR sky130_fd_sc_hd__decap_3
XFILLER_2_74 VGND VGND VPWR VPWR sky130_fd_sc_hd__fill_1
Xinput11 data2[2] VGND VGND VPWR VPWR net11 sky130_fd_sc_hd__buf_1
XFILLER_14_6 VGND VGND VPWR VPWR sky130_fd_sc_hd__decap_3
XFILLER_7_102 VGND VGND VPWR VPWR sky130_fd_sc_hd__decap_3
XFILLER_12_3 VGND VGND VPWR VPWR sky130_fd_sc_hd__decap_3
XFILLER_5_96 VGND VGND VPWR VPWR sky130_fd_sc_hd__fill_2
XFILLER_5_74 VGND VGND VPWR VPWR sky130_fd_sc_hd__decap_3
XFILLER_14_50 VGND VGND VPWR VPWR sky130_fd_sc_hd__decap_3
XFILLER_14_72 VGND VGND VPWR VPWR sky130_fd_sc_hd__decap_3
Xinput9 data2[0] VGND VGND VPWR VPWR net9 sky130_fd_sc_hd__clkbuf_2
X_197_ net34 _085_ VGND VGND VPWR VPWR _000_ sky130_fd_sc_hd__or2_1
XPHY_EDGE_ROW_10_Right_10 VGND VGND VPWR VPWR sky130_fd_sc_hd__decap_3
XFILLER_2_97 VGND VGND VPWR VPWR sky130_fd_sc_hd__decap_3
XFILLER_11_84 VGND VGND VPWR VPWR sky130_fd_sc_hd__fill_2
X_249_ net7 net33 _046_ VGND VGND VPWR VPWR _047_ sky130_fd_sc_hd__a21o_1
Xinput12 data2[3] VGND VGND VPWR VPWR net12 sky130_fd_sc_hd__buf_1
XFILLER_8_63 VGND VGND VPWR VPWR sky130_fd_sc_hd__decap_3
XFILLER_8_52 VGND VGND VPWR VPWR sky130_fd_sc_hd__fill_1
XFILLER_17_72 VGND VGND VPWR VPWR sky130_fd_sc_hd__fill_1
XFILLER_17_83 VGND VGND VPWR VPWR sky130_fd_sc_hd__fill_1
XPHY_EDGE_ROW_8_Right_8 VGND VGND VPWR VPWR sky130_fd_sc_hd__decap_3
XFILLER_5_53 VGND VGND VPWR VPWR sky130_fd_sc_hd__decap_3
XFILLER_5_31 VGND VGND VPWR VPWR sky130_fd_sc_hd__decap_3
XFILLER_6_9 VGND VGND VPWR VPWR sky130_fd_sc_hd__decap_3
XFILLER_4_6 VGND VGND VPWR VPWR sky130_fd_sc_hd__decap_3
X_196_ net6 _109_ net29 net36 _124_ VGND VGND VPWR VPWR _125_ sky130_fd_sc_hd__a221o_1
XFILLER_2_21 VGND VGND VPWR VPWR sky130_fd_sc_hd__decap_3
X_248_ net6 _083_ _109_ net43 _084_ VGND VGND VPWR VPWR _046_ sky130_fd_sc_hd__a221o_1
Xinput13 data2[4] VGND VGND VPWR VPWR net13 sky130_fd_sc_hd__clkbuf_1
X_179_ net41 net39 net37 VGND VGND VPWR VPWR _109_ sky130_fd_sc_hd__and3b_2
XPHY_EDGE_ROW_10_Left_28 VGND VGND VPWR VPWR sky130_fd_sc_hd__decap_3
XFILLER_2_3 VGND VGND VPWR VPWR sky130_fd_sc_hd__decap_3
XFILLER_8_97 VGND VGND VPWR VPWR sky130_fd_sc_hd__decap_3
XFILLER_8_75 VGND VGND VPWR VPWR sky130_fd_sc_hd__decap_3
XFILLER_17_51 VGND VGND VPWR VPWR sky130_fd_sc_hd__fill_1
XFILLER_17_95 VGND VGND VPWR VPWR sky130_fd_sc_hd__decap_3
XTAP_TAPCELL_ROW_4_43 VGND VPWR sky130_fd_sc_hd__tapvpwrvgnd_1
XPHY_EDGE_ROW_13_Left_31 VGND VGND VPWR VPWR sky130_fd_sc_hd__decap_3
XFILLER_5_65 VGND VGND VPWR VPWR sky130_fd_sc_hd__decap_3
XFILLER_14_85 VGND VGND VPWR VPWR sky130_fd_sc_hd__decap_3
X_195_ _081_ _091_ _093_ net43 VGND VGND VPWR VPWR _124_ sky130_fd_sc_hd__a22o_1
XFILLER_2_88 VGND VGND VPWR VPWR sky130_fd_sc_hd__decap_3
Xmax_cap29 _110_ VGND VGND VPWR VPWR net29 sky130_fd_sc_hd__clkbuf_2
XFILLER_11_31 VGND VGND VPWR VPWR sky130_fd_sc_hd__fill_2
X_247_ _043_ _044_ VGND VGND VPWR VPWR _045_ sky130_fd_sc_hd__nor2_1
Xinput14 data2[5] VGND VGND VPWR VPWR net14 sky130_fd_sc_hd__clkbuf_1
X_178_ net35 net33 _083_ net36 _084_ VGND VGND VPWR VPWR _108_ sky130_fd_sc_hd__a221o_1
XFILLER_14_9 VGND VGND VPWR VPWR sky130_fd_sc_hd__fill_1
XFILLER_8_21 VGND VGND VPWR VPWR sky130_fd_sc_hd__decap_3
XTAP_TAPCELL_ROW_17_63 VGND VPWR sky130_fd_sc_hd__tapvpwrvgnd_1
XFILLER_17_63 VGND VGND VPWR VPWR sky130_fd_sc_hd__decap_3
XFILLER_17_85 VGND VGND VPWR VPWR sky130_fd_sc_hd__decap_3
XTAP_TAPCELL_ROW_4_44 VGND VPWR sky130_fd_sc_hd__tapvpwrvgnd_1
XFILLER_0_100 VGND VGND VPWR VPWR sky130_fd_sc_hd__decap_3
XFILLER_5_77 VGND VGND VPWR VPWR sky130_fd_sc_hd__fill_2
XFILLER_14_53 VGND VGND VPWR VPWR sky130_fd_sc_hd__decap_3
XFILLER_14_75 VGND VGND VPWR VPWR sky130_fd_sc_hd__decap_3
X_194_ net35 _083_ _087_ net5 _084_ VGND VGND VPWR VPWR _123_ sky130_fd_sc_hd__a221o_1
XFILLER_2_12 VGND VGND VPWR VPWR sky130_fd_sc_hd__decap_3
XTAP_TAPCELL_ROW_11_54 VGND VPWR sky130_fd_sc_hd__tapvpwrvgnd_1
XFILLER_11_43 VGND VGND VPWR VPWR sky130_fd_sc_hd__decap_3
X_246_ _069_ _073_ _074_ _079_ VGND VGND VPWR VPWR _044_ sky130_fd_sc_hd__a31o_1
Xinput15 data2[6] VGND VGND VPWR VPWR net15 sky130_fd_sc_hd__clkbuf_1
X_177_ _061_ _104_ _105_ VGND VGND VPWR VPWR _107_ sky130_fd_sc_hd__nand3_1
X_229_ net8 net33 _083_ net34 _084_ VGND VGND VPWR VPWR _029_ sky130_fd_sc_hd__a221o_1
XFILLER_8_66 VGND VGND VPWR VPWR sky130_fd_sc_hd__decap_3
XTAP_TAPCELL_ROW_17_64 VGND VPWR sky130_fd_sc_hd__tapvpwrvgnd_1
XPHY_EDGE_ROW_17_Right_17 VGND VGND VPWR VPWR sky130_fd_sc_hd__decap_3
XFILLER_5_34 VGND VGND VPWR VPWR sky130_fd_sc_hd__fill_2
XFILLER_5_12 VGND VGND VPWR VPWR sky130_fd_sc_hd__decap_3
XFILLER_14_21 VGND VGND VPWR VPWR sky130_fd_sc_hd__decap_3
XFILLER_14_32 VGND VGND VPWR VPWR sky130_fd_sc_hd__fill_2
X_193_ _102_ _107_ _119_ _089_ VGND VGND VPWR VPWR _122_ sky130_fd_sc_hd__a211o_1
XFILLER_4_9 VGND VGND VPWR VPWR sky130_fd_sc_hd__decap_3
XFILLER_2_24 VGND VGND VPWR VPWR sky130_fd_sc_hd__decap_3
XFILLER_2_6 VGND VGND VPWR VPWR sky130_fd_sc_hd__decap_3
X_245_ _069_ _074_ _073_ VGND VGND VPWR VPWR _043_ sky130_fd_sc_hd__a21oi_1
Xinput16 data2[7] VGND VGND VPWR VPWR net16 sky130_fd_sc_hd__clkbuf_1
X_176_ _061_ _105_ _104_ VGND VGND VPWR VPWR _106_ sky130_fd_sc_hd__a21o_1
XFILLER_0_3 VGND VGND VPWR VPWR sky130_fd_sc_hd__decap_3
X_228_ net5 net31 _110_ net6 _027_ VGND VGND VPWR VPWR _028_ sky130_fd_sc_hd__a221o_1
X_159_ net8 net37 VGND VGND VPWR VPWR _090_ sky130_fd_sc_hd__or2_1
XTAP_TAPCELL_ROW_17_65 VGND VPWR sky130_fd_sc_hd__tapvpwrvgnd_1
XFILLER_8_78 VGND VGND VPWR VPWR sky130_fd_sc_hd__decap_3
XFILLER_17_98 VGND VGND VPWR VPWR sky130_fd_sc_hd__decap_3
XFILLER_5_68 VGND VGND VPWR VPWR sky130_fd_sc_hd__decap_3
XPHY_EDGE_ROW_17_Left_35 VGND VGND VPWR VPWR sky130_fd_sc_hd__decap_3
XFILLER_14_88 VGND VGND VPWR VPWR sky130_fd_sc_hd__decap_3
X_192_ _089_ _119_ _107_ _102_ VGND VGND VPWR VPWR _121_ sky130_fd_sc_hd__o211ai_1
XFILLER_2_58 VGND VGND VPWR VPWR sky130_fd_sc_hd__fill_1
XFILLER_11_12 VGND VGND VPWR VPWR sky130_fd_sc_hd__decap_3
X_244_ _039_ _041_ _042_ _058_ net9 VGND VGND VPWR VPWR net20 sky130_fd_sc_hd__o32a_1
Xinput17 op[0] VGND VGND VPWR VPWR net17 sky130_fd_sc_hd__buf_2
X_175_ _064_ _076_ _060_ _063_ VGND VGND VPWR VPWR _105_ sky130_fd_sc_hd__a211o_1
XPHY_EDGE_ROW_5_Left_23 VGND VGND VPWR VPWR sky130_fd_sc_hd__decap_3
X_227_ net4 net32 _109_ net36 VGND VGND VPWR VPWR _027_ sky130_fd_sc_hd__a22o_1
X_158_ net8 net38 VGND VGND VPWR VPWR _089_ sky130_fd_sc_hd__nor2_1
XFILLER_8_24 VGND VGND VPWR VPWR sky130_fd_sc_hd__decap_3
XFILLER_17_55 VGND VGND VPWR VPWR sky130_fd_sc_hd__fill_1
XFILLER_17_66 VGND VGND VPWR VPWR sky130_fd_sc_hd__decap_3
XFILLER_17_77 VGND VGND VPWR VPWR sky130_fd_sc_hd__decap_3
XFILLER_3_100 VGND VGND VPWR VPWR sky130_fd_sc_hd__fill_2
XFILLER_0_103 VGND VGND VPWR VPWR sky130_fd_sc_hd__fill_2
XFILLER_0_91 VGND VGND VPWR VPWR sky130_fd_sc_hd__decap_3
XPHY_EDGE_ROW_3_Right_3 VGND VGND VPWR VPWR sky130_fd_sc_hd__decap_3
XFILLER_14_56 VGND VGND VPWR VPWR sky130_fd_sc_hd__fill_1
XFILLER_14_78 VGND VGND VPWR VPWR sky130_fd_sc_hd__decap_3
X_260_ _118_ _004_ _056_ net26 VGND VGND VPWR VPWR net28 sky130_fd_sc_hd__o2bb2a_1
X_191_ net8 net38 VGND VGND VPWR VPWR _120_ sky130_fd_sc_hd__nand2_1
XFILLER_2_15 VGND VGND VPWR VPWR sky130_fd_sc_hd__decap_3
XFILLER_11_46 VGND VGND VPWR VPWR sky130_fd_sc_hd__fill_2
XFILLER_11_57 VGND VGND VPWR VPWR sky130_fd_sc_hd__decap_3
XFILLER_11_68 VGND VGND VPWR VPWR sky130_fd_sc_hd__decap_3
X_243_ net1 net9 net30 _057_ VGND VGND VPWR VPWR _042_ sky130_fd_sc_hd__a31o_1
Xinput18 op[1] VGND VGND VPWR VPWR net18 sky130_fd_sc_hd__buf_2
X_174_ _102_ _103_ VGND VGND VPWR VPWR _104_ sky130_fd_sc_hd__and2_1
X_226_ _024_ _025_ VGND VGND VPWR VPWR _026_ sky130_fd_sc_hd__nor2_1
X_157_ net41 net39 net37 VGND VGND VPWR VPWR _088_ sky130_fd_sc_hd__nor3_1
XFILLER_8_69 VGND VGND VPWR VPWR sky130_fd_sc_hd__decap_3
XFILLER_8_36 VGND VGND VPWR VPWR sky130_fd_sc_hd__fill_1
XFILLER_17_23 VGND VGND VPWR VPWR sky130_fd_sc_hd__fill_1
XFILLER_0_81 VGND VGND VPWR VPWR sky130_fd_sc_hd__decap_3
X_209_ net43 net9 _071_ _072_ VGND VGND VPWR VPWR _011_ sky130_fd_sc_hd__a22o_1
XFILLER_5_15 VGND VGND VPWR VPWR sky130_fd_sc_hd__decap_3
XPHY_EDGE_ROW_13_Right_13 VGND VGND VPWR VPWR sky130_fd_sc_hd__decap_3
XFILLER_14_24 VGND VGND VPWR VPWR sky130_fd_sc_hd__decap_3
X_190_ net8 net38 VGND VGND VPWR VPWR _119_ sky130_fd_sc_hd__and2_1
XFILLER_2_49 VGND VGND VPWR VPWR sky130_fd_sc_hd__decap_3
XFILLER_2_27 VGND VGND VPWR VPWR sky130_fd_sc_hd__fill_1
X_242_ net1 net9 _099_ _040_ VGND VGND VPWR VPWR _041_ sky130_fd_sc_hd__o22a_1
Xinput19 op[2] VGND VGND VPWR VPWR net19 sky130_fd_sc_hd__clkbuf_2
X_173_ net40 net34 VGND VGND VPWR VPWR _103_ sky130_fd_sc_hd__or2_1
XTAP_TAPCELL_ROW_7_48 VGND VPWR sky130_fd_sc_hd__tapvpwrvgnd_1
XFILLER_2_9 VGND VGND VPWR VPWR sky130_fd_sc_hd__decap_3
XFILLER_0_6 VGND VGND VPWR VPWR sky130_fd_sc_hd__decap_3
XFILLER_3_92 VGND VGND VPWR VPWR sky130_fd_sc_hd__decap_3
X_225_ _067_ _068_ _075_ _079_ VGND VGND VPWR VPWR _025_ sky130_fd_sc_hd__a31o_1
X_156_ net39 net37 net41 VGND VGND VPWR VPWR _087_ sky130_fd_sc_hd__and3b_2
XFILLER_8_15 VGND VGND VPWR VPWR sky130_fd_sc_hd__decap_3
XFILLER_17_57 VGND VGND VPWR VPWR sky130_fd_sc_hd__fill_2
XFILLER_0_60 VGND VGND VPWR VPWR sky130_fd_sc_hd__decap_3
X_208_ net43 _085_ _096_ _009_ VGND VGND VPWR VPWR _010_ sky130_fd_sc_hd__o211a_1
X_139_ net36 net10 VGND VGND VPWR VPWR _070_ sky130_fd_sc_hd__and2_1
XTAP_TAPCELL_ROW_1_39 VGND VPWR sky130_fd_sc_hd__tapvpwrvgnd_1
XTAP_TAPCELL_ROW_14_58 VGND VPWR sky130_fd_sc_hd__tapvpwrvgnd_1
XFILLER_6_92 VGND VGND VPWR VPWR sky130_fd_sc_hd__fill_2
XFILLER_17_101 VGND VGND VPWR VPWR sky130_fd_sc_hd__decap_3
XFILLER_9_3 VGND VGND VPWR VPWR sky130_fd_sc_hd__fill_2
XFILLER_11_15 VGND VGND VPWR VPWR sky130_fd_sc_hd__decap_3
X_241_ net1 net9 _079_ VGND VGND VPWR VPWR _040_ sky130_fd_sc_hd__a21oi_1
X_172_ net40 net34 VGND VGND VPWR VPWR _102_ sky130_fd_sc_hd__nand2_1
X_224_ _067_ _068_ _075_ VGND VGND VPWR VPWR _024_ sky130_fd_sc_hd__a21oi_1
X_155_ net36 net33 _083_ net43 _084_ VGND VGND VPWR VPWR _086_ sky130_fd_sc_hd__a221o_1
XFILLER_8_49 VGND VGND VPWR VPWR sky130_fd_sc_hd__decap_3
XFILLER_8_27 VGND VGND VPWR VPWR sky130_fd_sc_hd__fill_1
XFILLER_17_69 VGND VGND VPWR VPWR sky130_fd_sc_hd__decap_3
XPHY_EDGE_ROW_9_Left_27 VGND VGND VPWR VPWR sky130_fd_sc_hd__decap_3
X_207_ _005_ _006_ _007_ _008_ VGND VGND VPWR VPWR _009_ sky130_fd_sc_hd__or4_1
X_138_ net35 net11 VGND VGND VPWR VPWR _069_ sky130_fd_sc_hd__nand2_1
XFILLER_0_50 VGND VGND VPWR VPWR sky130_fd_sc_hd__decap_3
XFILLER_0_72 VGND VGND VPWR VPWR sky130_fd_sc_hd__decap_3
XFILLER_0_94 VGND VGND VPWR VPWR sky130_fd_sc_hd__decap_3
XFILLER_5_28 VGND VGND VPWR VPWR sky130_fd_sc_hd__decap_3
XFILLER_14_15 VGND VGND VPWR VPWR sky130_fd_sc_hd__decap_3
XTAP_TAPCELL_ROW_14_59 VGND VPWR sky130_fd_sc_hd__tapvpwrvgnd_1
XPHY_EDGE_ROW_7_Right_7 VGND VGND VPWR VPWR sky130_fd_sc_hd__decap_3
XFILLER_6_82 VGND VGND VPWR VPWR sky130_fd_sc_hd__fill_2
XFILLER_2_18 VGND VGND VPWR VPWR sky130_fd_sc_hd__decap_3
X_240_ net8 _085_ _096_ _038_ VGND VGND VPWR VPWR _039_ sky130_fd_sc_hd__o211a_1
X_171_ _059_ _101_ VGND VGND VPWR VPWR net25 sky130_fd_sc_hd__and2_1
X_223_ _016_ _021_ _023_ _058_ net13 VGND VGND VPWR VPWR net24 sky130_fd_sc_hd__o32a_1
X_154_ net37 _083_ VGND VGND VPWR VPWR _085_ sky130_fd_sc_hd__nand2_2
XFILLER_17_48 VGND VGND VPWR VPWR sky130_fd_sc_hd__decap_3
X_206_ net34 _087_ net31 net35 VGND VGND VPWR VPWR _008_ sky130_fd_sc_hd__a22o_1
X_137_ net4 net12 VGND VGND VPWR VPWR _068_ sky130_fd_sc_hd__or2_1
XFILLER_17_3 VGND VGND VPWR VPWR sky130_fd_sc_hd__decap_3
XFILLER_9_71 VGND VGND VPWR VPWR sky130_fd_sc_hd__decap_3
XFILLER_14_27 VGND VGND VPWR VPWR sky130_fd_sc_hd__fill_1
XPHY_EDGE_ROW_12_Left_30 VGND VGND VPWR VPWR sky130_fd_sc_hd__decap_3
XTAP_TAPCELL_ROW_2_40 VGND VPWR sky130_fd_sc_hd__tapvpwrvgnd_1
XFILLER_11_28 VGND VGND VPWR VPWR sky130_fd_sc_hd__decap_3
X_170_ _078_ _080_ _097_ _100_ VGND VGND VPWR VPWR _101_ sky130_fd_sc_hd__a211o_1
XFILLER_0_9 VGND VGND VPWR VPWR sky130_fd_sc_hd__decap_3
XFILLER_12_82 VGND VGND VPWR VPWR sky130_fd_sc_hd__fill_2
X_222_ _063_ net30 _022_ VGND VGND VPWR VPWR _023_ sky130_fd_sc_hd__a21o_1
X_153_ net41 net39 net37 VGND VGND VPWR VPWR _084_ sky130_fd_sc_hd__and3_2
XTAP_TAPCELL_ROW_8_50 VGND VPWR sky130_fd_sc_hd__tapvpwrvgnd_1
XFILLER_8_18 VGND VGND VPWR VPWR sky130_fd_sc_hd__decap_3
XFILLER_17_16 VGND VGND VPWR VPWR sky130_fd_sc_hd__fill_1
X_205_ net5 _083_ _109_ net8 _084_ VGND VGND VPWR VPWR _007_ sky130_fd_sc_hd__a221o_1
X_136_ net4 net12 VGND VGND VPWR VPWR _067_ sky130_fd_sc_hd__nand2_1
XFILLER_0_41 VGND VGND VPWR VPWR sky130_fd_sc_hd__decap_3
XFILLER_0_63 VGND VGND VPWR VPWR sky130_fd_sc_hd__decap_3
XFILLER_0_85 VGND VGND VPWR VPWR sky130_fd_sc_hd__decap_3
XFILLER_6_73 VGND VGND VPWR VPWR sky130_fd_sc_hd__decap_3
XFILLER_17_104 VGND VGND VPWR VPWR sky130_fd_sc_hd__fill_1
XTAP_TAPCELL_ROW_15_60 VGND VPWR sky130_fd_sc_hd__tapvpwrvgnd_1
XTAP_TAPCELL_ROW_2_41 VGND VPWR sky130_fd_sc_hd__tapvpwrvgnd_1
XFILLER_3_30 VGND VGND VPWR VPWR sky130_fd_sc_hd__fill_1
XFILLER_12_50 VGND VGND VPWR VPWR sky130_fd_sc_hd__decap_3
X_221_ net17 _064_ net30 _057_ VGND VGND VPWR VPWR _022_ sky130_fd_sc_hd__a31o_1
X_152_ net41 net39 VGND VGND VPWR VPWR _083_ sky130_fd_sc_hd__and2_2
X_204_ net4 _110_ VGND VGND VPWR VPWR _006_ sky130_fd_sc_hd__and2_1
XFILLER_0_53 VGND VGND VPWR VPWR sky130_fd_sc_hd__decap_3
XFILLER_0_75 VGND VGND VPWR VPWR sky130_fd_sc_hd__decap_3
XFILLER_0_97 VGND VGND VPWR VPWR sky130_fd_sc_hd__decap_3
X_135_ net4 net12 VGND VGND VPWR VPWR _066_ sky130_fd_sc_hd__and2_1
XFILLER_14_18 VGND VGND VPWR VPWR sky130_fd_sc_hd__decap_3
XFILLER_14_29 VGND VGND VPWR VPWR sky130_fd_sc_hd__decap_3
XFILLER_6_52 VGND VGND VPWR VPWR sky130_fd_sc_hd__decap_3
XFILLER_3_75 VGND VGND VPWR VPWR sky130_fd_sc_hd__fill_1
X_220_ net4 _085_ _096_ _020_ VGND VGND VPWR VPWR _021_ sky130_fd_sc_hd__o211a_1
X_151_ net41 net39 net37 VGND VGND VPWR VPWR _082_ sky130_fd_sc_hd__nor3b_1
XFILLER_17_29 VGND VGND VPWR VPWR sky130_fd_sc_hd__fill_1
XFILLER_0_21 VGND VGND VPWR VPWR sky130_fd_sc_hd__decap_3
XFILLER_0_32 VGND VGND VPWR VPWR sky130_fd_sc_hd__decap_3
XFILLER_17_6 VGND VGND VPWR VPWR sky130_fd_sc_hd__decap_3
X_203_ net6 net33 net32 net36 VGND VGND VPWR VPWR _005_ sky130_fd_sc_hd__a22o_1
X_134_ _063_ _064_ VGND VGND VPWR VPWR _065_ sky130_fd_sc_hd__and2b_1
XFILLER_9_30 VGND VGND VPWR VPWR sky130_fd_sc_hd__decap_3
XFILLER_9_74 VGND VGND VPWR VPWR sky130_fd_sc_hd__fill_1
XFILLER_15_3 VGND VGND VPWR VPWR sky130_fd_sc_hd__fill_2
XPHY_EDGE_ROW_16_Left_34 VGND VGND VPWR VPWR sky130_fd_sc_hd__decap_3
XPHY_EDGE_ROW_1_Left_19 VGND VGND VPWR VPWR sky130_fd_sc_hd__decap_3
XFILLER_3_21 VGND VGND VPWR VPWR sky130_fd_sc_hd__decap_3
XFILLER_12_41 VGND VGND VPWR VPWR sky130_fd_sc_hd__decap_3
XFILLER_12_63 VGND VGND VPWR VPWR sky130_fd_sc_hd__decap_3
XFILLER_12_85 VGND VGND VPWR VPWR sky130_fd_sc_hd__fill_2
X_150_ net41 net39 VGND VGND VPWR VPWR _081_ sky130_fd_sc_hd__nor2_1
XPHY_EDGE_ROW_16_Right_16 VGND VGND VPWR VPWR sky130_fd_sc_hd__decap_3
XFILLER_0_44 VGND VGND VPWR VPWR sky130_fd_sc_hd__decap_3
X_202_ _118_ _004_ VGND VGND VPWR VPWR net27 sky130_fd_sc_hd__and2_1
X_133_ net5 net13 VGND VGND VPWR VPWR _064_ sky130_fd_sc_hd__or2_1
XPHY_EDGE_ROW_4_Left_22 VGND VGND VPWR VPWR sky130_fd_sc_hd__decap_3
XFILLER_0_66 VGND VGND VPWR VPWR sky130_fd_sc_hd__decap_3
XFILLER_0_88 VGND VGND VPWR VPWR sky130_fd_sc_hd__decap_3
XFILLER_9_97 VGND VGND VPWR VPWR sky130_fd_sc_hd__fill_2
XPHY_EDGE_ROW_2_Right_2 VGND VGND VPWR VPWR sky130_fd_sc_hd__decap_3
XFILLER_6_76 VGND VGND VPWR VPWR sky130_fd_sc_hd__decap_3
XFILLER_6_65 VGND VGND VPWR VPWR sky130_fd_sc_hd__fill_1
XFILLER_6_43 VGND VGND VPWR VPWR sky130_fd_sc_hd__decap_3
XFILLER_15_85 VGND VGND VPWR VPWR sky130_fd_sc_hd__decap_3
XFILLER_12_53 VGND VGND VPWR VPWR sky130_fd_sc_hd__decap_3
X_201_ _078_ _121_ _122_ _003_ VGND VGND VPWR VPWR _004_ sky130_fd_sc_hd__a31o_1
X_132_ net5 net13 VGND VGND VPWR VPWR _063_ sky130_fd_sc_hd__and2_1
XFILLER_0_12 VGND VGND VPWR VPWR sky130_fd_sc_hd__decap_3
XFILLER_0_78 VGND VGND VPWR VPWR sky130_fd_sc_hd__decap_3
XFILLER_9_65 VGND VGND VPWR VPWR sky130_fd_sc_hd__decap_3
XFILLER_6_55 VGND VGND VPWR VPWR sky130_fd_sc_hd__fill_2
XFILLER_15_97 VGND VGND VPWR VPWR sky130_fd_sc_hd__fill_1
.ends
